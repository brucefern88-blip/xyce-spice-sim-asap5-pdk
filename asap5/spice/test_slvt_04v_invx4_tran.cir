* test_slvt_04v_invx4_tran.cir — INVx4 SLVT (M=4) Transient @ VDD=0.40V
.include '/Users/bruce/CLAUDE/asap5/spice/xyce_models/nmos_slvt_tt_cal.pm'
.include '/Users/bruce/CLAUDE/asap5/spice/xyce_models/pmos_slvt_tt_cal.pm'
.include '/Users/bruce/CLAUDE/asap5/spice/xyce_models/asap5_inv_lib.sp'
.OPTIONS DEVICE GMIN=1e-12
.OPTIONS NONLIN RELTOL=1e-4 ABSTOL=1e-9
.OPTIONS TIMEINT METHOD=trap RELTOL=1e-3 ABSTOL=1e-12
.OPTIONS MEASURE MEASDGT=5
.param vdd_val = 0.4
vdd vdd 0 dc {vdd_val}
vss vss 0 dc 0
vin in 0 pulse(0 {vdd_val} 100p 10p 10p 190p 400p)
xinv in out vdd vss INVx4
cload out 0 1.0f
.TRAN 1p 800p
.PRINT TRAN V(in) V(out)
.MEASURE TRAN tphl TRIG V(in) VAL={vdd_val/2} RISE=1 TARG V(out) VAL={vdd_val/2} FALL=1
.MEASURE TRAN tplh TRIG V(in) VAL={vdd_val/2} FALL=1 TARG V(out) VAL={vdd_val/2} RISE=1
.MEASURE TRAN fall_time TRIG V(out) VAL={vdd_val*0.9} FALL=1 TARG V(out) VAL={vdd_val*0.1} FALL=1
.MEASURE TRAN rise_time TRIG V(out) VAL={vdd_val*0.1} RISE=1 TARG V(out) VAL={vdd_val*0.9} RISE=1
.MEASURE TRAN avg_idd AVG I(vdd) FROM=100p TO=500p
.MEASURE TRAN e_total INTEG {V(vdd)*I(vdd)} FROM=100p TO=500p
.END
