* =============================================================================
* test_asap5_inv_xyce_dc.cir — ASAP5 Inverter VTC (DC sweep) for Xyce
* =============================================================================
* LVT nanosheet GAA devices at VDD=0.7V
* Run:  Xyce test_asap5_inv_xyce_dc.cir
* =============================================================================

.include '/Users/bruce/CLAUDE/asap5/spice/xyce_models/nmos_lvt_tt.pm'
.include '/Users/bruce/CLAUDE/asap5/spice/xyce_models/pmos_lvt_tt.pm'

* --- High-Precision Solver Options ---
* Tight nonlinear convergence for sub-mV accuracy on FinFET/GAA
.OPTIONS NONLIN RELTOL=1e-6 ABSTOL=1e-12
* Precise charge conservation and nanovolt node resolution
.OPTIONS DEVICE VNTOL=1e-9 CHGTOL=1e-16 GMIN=1e-15

.param vdd_val = 0.7

vdd  vdd  0  dc {vdd_val}
vss  vss  0  dc 0
vin  in   0  dc 0

mp1  out in  vdd vdd pmos_lvt
mn1  out in  vss vss nmos_lvt

cload out 0 1.6f

.DC vin 0 0.7 0.001
.PRINT DC V(in) V(out)
.MEASURE DC v_trip FIND V(in) WHEN V(out)=0.35

.END
