* =============================================================================
* test_asap5_inverter_xyce.cir — ASAP5 CMOS Inverter for Xyce
* =============================================================================
*
* DC VTC sweep and transient propagation delay measurement.
* LVT devices at VDD=0.7V (nominal ASAP5 nanosheet GAA).
*
* Run:  Xyce test_asap5_inverter_xyce.cir
* =============================================================================

* --- Include ASAP5 BSIM-CMG models (TT corner) ---
.lib '/Users/bruce/CLAUDE/asap5/spice/asap5_ngspice.lib' tt

* --- High-Precision Solver Options ---
* Tight nonlinear convergence for sub-mV accuracy on FinFET/GAA
.OPTIONS NONLIN RELTOL=1e-6 ABSTOL=1e-12
* LTE control: TRTOL=1.0 forces strict adaptive time-stepping
.OPTIONS TIMEINT METHOD=trap RELTOL=1e-6 ABSTOL=1e-15 TRTOL=1.0
* Precise charge conservation and nanovolt node resolution
.OPTIONS DEVICE VNTOL=1e-9 CHGTOL=1e-16 GMIN=1e-15

.param vdd_val = 0.7

* ── Supply ──
vdd  vdd  0  dc {vdd_val}
vss  vss  0  dc 0

* ── Inverter under test ──
mp1  out in  vdd vdd pmos_lvt
mn1  out in  vss vss nmos_lvt

* ── Load capacitor (gate + wire ~ 1.6 fF) ──
cload out 0 1.6f

* ── Input: DC value for sweep + PULSE for transient ──
* Xyce uses both specs: .DC sweeps the DC value; .TRAN uses the PULSE.
vin  in  0  dc 0 pulse(0 0.7 50p 5p 5p 95p 200p)

* =============================================================================
* DC Analysis: VTC sweep, Vin = 0 to 0.7V
* =============================================================================
.DC vin 0 0.7 0.001
.PRINT DC V(in) V(out)
.MEASURE DC v_trip FIND V(in) WHEN V(out)=0.35

* =============================================================================
* Transient Analysis: propagation delay at 0.7V
* =============================================================================
* DTMAX=1p prevents aliasing of fast transitions
.TRAN 0.5p 400p 0 1p
.PRINT TRAN V(in) V(out)
.MEASURE TRAN tphl TRIG V(in) VAL=0.35 RISE=1 TARG V(out) VAL=0.35 FALL=1
.MEASURE TRAN tplh TRIG V(in) VAL=0.35 FALL=1 TARG V(out) VAL=0.35 RISE=1

.END
