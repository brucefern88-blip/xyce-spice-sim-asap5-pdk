* =============================================================================
* test_invx1_xyce_dc.cir — ASAP5 INVx1 (extracted) DC VTC for Xyce
* =============================================================================
* INVx1 subcircuit with Magic-extracted parasitics
* LVT GAA nanosheet, TT corner, VDD=0.7V
* Run:  Xyce test_invx1_xyce_dc.cir
* =============================================================================

.include '/Users/bruce/CLAUDE/asap5/spice/xyce_models/nmos_lvt_tt.pm'
.include '/Users/bruce/CLAUDE/asap5/spice/xyce_models/pmos_lvt_tt.pm'

* === Xyce Global Options for FinFET/GAA Designs ===
.OPTIONS DEVICE GMIN=1e-12
.OPTIONS NONLIN RELTOL=1e-4 ABSTOL=1e-9
.OPTIONS MEASURE MEASDGT=5

* --- INVx1 extracted subcircuit (Magic parasitics) ---
.subckt INVx1 A Y VDD VSS
mn1 Y A VSS VSS nmos_lvt l=16n
mp1 Y A VDD VDD pmos_lvt l=16n
Cext_Y Y 0 0.9653f
Cext_A A 0 0.2206f
.ends INVx1

* --- Testbench ---
.param vdd_val = 0.7

vdd  vdd  0  dc {vdd_val}
vss  vss  0  dc 0
vin  in   0  dc 0

xinv in out vdd vss INVx1

cload out 0 1.0f

.DC vin 0 {vdd_val} 0.001
.PRINT DC V(in) V(out)
.MEASURE DC v_trip FIND V(in) WHEN V(out)={vdd_val/2}
.MEASURE DC v_ol  FIND V(out) WHEN V(in)=0.6
.MEASURE DC v_oh  FIND V(out) WHEN V(in)=0.1

.END
