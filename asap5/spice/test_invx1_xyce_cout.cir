* =============================================================================
* test_invx1_xyce_cout.cir — ASAP5 INVx1 Output Capacitance (Cout) via AC
* =============================================================================
* Cout_total = Im(I(vout)) / (2*pi*f) — device drain caps only
* INVx1: 2 nfin NMOS + 2 nfin PMOS, LVT TT, VDD=0.7V
* Bias: input=0 (PMOS on, NMOS off), AC excitation at output
* Run:  Xyce test_invx1_xyce_cout.cir
* =============================================================================

.include '/Users/bruce/CLAUDE/asap5/spice/xyce_models/nmos_lvt_tt.pm'
.include '/Users/bruce/CLAUDE/asap5/spice/xyce_models/pmos_lvt_tt.pm'

* === Xyce Global Options ===
.OPTIONS DEVICE GMIN=1e-12
.OPTIONS NONLIN RELTOL=1e-4 ABSTOL=1e-9
.OPTIONS MEASURE MEASDGT=5

.param vdd_val = 0.7

vdd  vdd  0  dc {vdd_val}
vss  vss  0  dc 0
vin  in   0  dc 0

* Output forced to VDD (matches DC OP with input=0) + AC probe
vout out  0  dc {vdd_val} ac 1

mp1  out in  vdd vdd pmos_lvt l=16n nfin=2
mn1  out in  vss vss nmos_lvt l=16n nfin=2

.AC DEC 10 1e8 1e11
.PRINT AC II(vout) IR(vout) IM(vout) IP(vout)

.END
