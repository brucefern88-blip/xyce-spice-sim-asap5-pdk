* Extracted subcircuit for XNOR2x2
* Magic layout extraction parasitics from XNOR2x2.ext
* Devices: 0 ()
* Total extracted node cap: 19.7 fF
*
.subckt XNOR2x2 A B Y VDD VSS
mn_invb BB B VSS VSS nmos_lvt l=16n nfin=4
mp_invb BB B VDD VDD pmos_lvt l=16n nfin=4
mn_inva AB A VSS VSS nmos_lvt l=16n nfin=4
mp_inva AB A VDD VDD pmos_lvt l=16n nfin=4
mn_tg1 AB B Y VSS nmos_lvt l=16n nfin=4
mp_tg1 AB BB Y VDD pmos_lvt l=16n nfin=4
mn_tg2 A BB Y VSS nmos_lvt l=16n nfin=4
mp_tg2 A B Y VDD pmos_lvt l=16n nfin=4
* --- Extracted parasitic capacitances ---
Cext_Y Y 0 6.8960f
Cext_A A 0 1.5762f
Cext_B B 0 1.5762f
Cext_BB BB 0 2.3644f
Cext_AB AB 0 2.3644f
.ends
