* DFFx1 functional verification
* Positive-edge-triggered D flip-flop, ASAP5 5nm GAA
* Test: CLK at 2GHz, D pattern 1,0,1,1,0 — verify Q captures D on rising CLK edges

.include '/Users/bruce/CLAUDE/asap5/spice/xyce_models/nmos_lvt_tt_cal.pm'
.include '/Users/bruce/CLAUDE/asap5/spice/xyce_models/pmos_lvt_tt_cal.pm'

.OPTIONS DEVICE GMIN=1e-12
.OPTIONS NONLIN RELTOL=1e-4 ABSTOL=1e-9
.OPTIONS TIMEINT METHOD=trap RELTOL=1e-3 ABSTOL=1e-12

.param vdd_val = 0.7
VDD vdd 0 DC {vdd_val}
VSS vss 0 DC 0

* CLK: 500ps period (2GHz), first rising edge at 100ps
VCLK clk 0 PULSE(0 {vdd_val} 100p 5p 5p 245p 500p)

* D: pattern 1,0,1,1,0 with 500ps per bit
* Bit 0 (0-500ps):   D=1 — captured at CLK rise #1 (100ps)
* Bit 1 (500-1000ps): D=0 — captured at CLK rise #2 (600ps)
* Bit 2 (1000-1500ps): D=1 — captured at CLK rise #3 (1100ps)
* Bit 3 (1500-2000ps): D=1 — captured at CLK rise #4 (1600ps)
* Bit 4 (2000-2500ps): D=0 — captured at CLK rise #5 (2100ps)
VD d 0 PWL(0 0 50p {vdd_val} 500p {vdd_val} 550p 0 1000p 0 1050p {vdd_val}
+ 1500p {vdd_val} 1550p {vdd_val} 2000p {vdd_val} 2050p 0 2500p 0)

.include '/Users/bruce/CLAUDE/asap5/charflow/cells/DFFx1/DFFx1.spice'
X1 d clk q vdd vss DFFx1

CLOAD q 0 1.0f

.NODESET V(q)=0

.TRAN 0.5p 3000p

.PRINT TRAN V(d) V(clk) V(q)

.MEASURE TRAN tpd_rise TRIG V(clk) VAL={vdd_val*0.5} RISE=1
+                      TARG V(q) VAL={vdd_val*0.5} RISE=1

.MEASURE TRAN tpd_fall TRIG V(clk) VAL={vdd_val*0.5} RISE=2
+                      TARG V(q) VAL={vdd_val*0.5} FALL=1

.END
