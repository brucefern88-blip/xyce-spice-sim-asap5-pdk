* NAND2x1 PPA @ 0.40V SLVT
.include '/Users/bruce/CLAUDE/asap5/spice/xyce_models/nmos_slvt_tt_cal.pm'
.include '/Users/bruce/CLAUDE/asap5/spice/xyce_models/pmos_slvt_tt_cal.pm'
.OPTIONS DEVICE GMIN=1e-12
.OPTIONS NONLIN RELTOL=1e-4 ABSTOL=1e-9
.OPTIONS TIMEINT METHOD=trap RELTOL=1e-3 ABSTOL=1e-12
.OPTIONS MEASURE MEASDGT=5
.param vdd_val = 0.40
VDD vdd 0 DC {vdd_val}
VSS vss 0 DC 0
VA in_a 0 PULSE(0 {vdd_val} 100p 10p 10p 390p 800p)
VB in_b 0 DC {vdd_val}

* NAND2x1 subcircuit — SLVT variant
.subckt NAND2x1_SLVT A B Y VDD VSS
mn1 mid A VSS VSS nmos_slvt l=16n nfin=2
mn2 Y B mid VSS nmos_slvt l=16n nfin=2
mp1 Y A VDD VDD pmos_slvt l=16n nfin=2
mp2 Y B VDD VDD pmos_slvt l=16n nfin=2
Cext_Y Y 0 0.070f
Cext_A A 0 0.035f
Cext_B B 0 0.035f
Cext_mid mid 0 0.040f
.ends NAND2x1_SLVT

X1 in_a in_b out vdd vss NAND2x1_SLVT
CLOAD out 0 1.0f
.TRAN 1p 1000p
.MEASURE TRAN tphl TRIG V(in_a) VAL={vdd_val*0.5} RISE=1 TARG V(out) VAL={vdd_val*0.5} FALL=1
.MEASURE TRAN tplh TRIG V(in_a) VAL={vdd_val*0.5} FALL=1 TARG V(out) VAL={vdd_val*0.5} RISE=1
.MEASURE TRAN avg_i AVG I(VDD) FROM=100p TO=500p
.MEASURE TRAN e_total INTEG I(VDD) FROM=100p TO=500p
.END
