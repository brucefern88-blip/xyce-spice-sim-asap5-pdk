.subckt MUX21x1 D0 D1 S Y VDD VSS
* S inverter
mn_invs SB S VSS VSS nmos_slvt l=16n nfin=2
mp_invs SB S VDD VDD pmos_slvt l=16n nfin=2
* TG0: passes D0 when S=0 (N-gate=SB, P-gate=S)
mn_tg0 D0 SB M VSS nmos_slvt l=16n nfin=2
mp_tg0 D0 S M VDD pmos_slvt l=16n nfin=2
* TG1: passes D1 when S=1 (N-gate=S, P-gate=SB)
mn_tg1 D1 S M VSS nmos_slvt l=16n nfin=2
mp_tg1 D1 SB M VDD pmos_slvt l=16n nfin=2
* Output inverter
mn_out Y M VSS VSS nmos_slvt l=16n nfin=2
mp_out Y M VDD VDD pmos_slvt l=16n nfin=2
Cext_Y Y 0 0.050f
Cext_M M 0 0.100f
Cext_D0 D0 0 0.040f
Cext_D1 D1 0 0.040f
Cext_S S 0 0.040f
Cext_SB SB 0 0.040f
.ends MUX21x1
