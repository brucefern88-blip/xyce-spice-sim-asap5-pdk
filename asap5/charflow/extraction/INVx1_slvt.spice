.subckt INVx1 A Y VDD VSS
mn1 Y A VSS VSS nmos_slvt l=16n nfin=2
mp1 Y A VDD VDD pmos_slvt l=16n nfin=2
* Layout-derived parasitic caps (scaled from ASAP5 geometry)
Cext_Y Y 0 0.050f
Cext_A A 0 0.030f
.ends INVx1
