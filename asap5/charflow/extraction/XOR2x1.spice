.subckt XOR2x1 A B Y VDD VSS
* 8T transmission-gate XOR: Y = A ^ B
* B inverter
mn_invb BB B VSS VSS nmos_lvt l=16n nfin=2
mp_invb BB B VDD VDD pmos_lvt l=16n nfin=2
* A inverter
mn_inva AB A VSS VSS nmos_lvt l=16n nfin=2
mp_inva AB A VDD VDD pmos_lvt l=16n nfin=2
* TG1: pass ~A when B=1 (N-gate=B, P-gate=BB)
mn_tg1 AB B Y VSS nmos_lvt l=16n nfin=2
mp_tg1 AB BB Y VDD pmos_lvt l=16n nfin=2
* TG2: pass A when B=0 (N-gate=BB, P-gate=B)
mn_tg2 A BB Y VSS nmos_lvt l=16n nfin=2
mp_tg2 A B Y VDD pmos_lvt l=16n nfin=2
* Layout parasitics — 176nm x 140nm, 8T TG XOR
Cext_Y Y 0 0.120f
Cext_A A 0 0.060f
Cext_B B 0 0.060f
Cext_BB BB 0 0.050f
Cext_AB AB 0 0.050f
.ends XOR2x1
