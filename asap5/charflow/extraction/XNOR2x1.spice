.subckt XNOR2x1 A B Y VDD VSS
* XOR core (same as XOR2x1 but output to internal node X)
mn_invb BB B VSS VSS nmos_lvt l=16n nfin=2
mp_invb BB B VDD VDD pmos_lvt l=16n nfin=2
mn_inva AB A VSS VSS nmos_lvt l=16n nfin=2
mp_inva AB A VDD VDD pmos_lvt l=16n nfin=2
mn_tg1 A B X VSS nmos_lvt l=16n nfin=2
mp_tg1 A BB X VDD pmos_lvt l=16n nfin=2
mn_tg2 AB BB X VSS nmos_lvt l=16n nfin=2
mp_tg2 AB B X VDD pmos_lvt l=16n nfin=2
* Output inverter
mn_out Y X VSS VSS nmos_lvt l=16n nfin=2
mp_out Y X VDD VDD pmos_lvt l=16n nfin=2
Cext_Y Y 0 0.050f
Cext_X X 0 0.120f
Cext_A A 0 0.060f
Cext_B B 0 0.060f
Cext_BB BB 0 0.050f
Cext_AB AB 0 0.050f
.ends XNOR2x1
