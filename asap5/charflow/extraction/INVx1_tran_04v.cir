* INVx1 PPA characterization @ 0.40V SLVT
.include '/Users/bruce/CLAUDE/asap5/spice/xyce_models/nmos_slvt_tt_cal.pm'
.include '/Users/bruce/CLAUDE/asap5/spice/xyce_models/pmos_slvt_tt_cal.pm'

.OPTIONS DEVICE GMIN=1e-12
.OPTIONS NONLIN RELTOL=1e-4 ABSTOL=1e-9
.OPTIONS TIMEINT METHOD=trap RELTOL=1e-3 ABSTOL=1e-12
.OPTIONS MEASURE MEASDGT=5

.param vdd_val = 0.40
VDD vdd 0 DC {vdd_val}
VSS vss 0 DC 0
VIN in 0 PULSE(0 {vdd_val} 100p 5p 5p 200p 500p)

.include '/Users/bruce/CLAUDE/asap5/charflow/extraction/INVx1_slvt.spice'
X1 in out vdd vss INVx1

CLOAD out 0 1.0f

.TRAN 0.5p 1000p

.MEASURE TRAN tphl TRIG V(in) VAL={vdd_val*0.5} RISE=1 TARG V(out) VAL={vdd_val*0.5} FALL=1
.MEASURE TRAN tplh TRIG V(in) VAL={vdd_val*0.5} FALL=1 TARG V(out) VAL={vdd_val*0.5} RISE=1
.MEASURE TRAN tfall TRIG V(out) VAL={vdd_val*0.8} FALL=1 TARG V(out) VAL={vdd_val*0.2} FALL=1
.MEASURE TRAN trise TRIG V(out) VAL={vdd_val*0.2} RISE=1 TARG V(out) VAL={vdd_val*0.8} RISE=1
.MEASURE TRAN avg_i AVG I(VDD) FROM=100p TO=600p
.MEASURE TRAN e_total INTEG I(VDD) FROM=100p TO=600p

.END
