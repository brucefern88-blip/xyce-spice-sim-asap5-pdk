* AOI21x1 PPA @ 0.40V SLVT — B->Y path (A0=A1=0, Y=!B)
.include '/Users/bruce/CLAUDE/asap5/spice/xyce_models/nmos_slvt_tt_cal.pm'
.include '/Users/bruce/CLAUDE/asap5/spice/xyce_models/pmos_slvt_tt_cal.pm'
.OPTIONS DEVICE GMIN=1e-12
.OPTIONS NONLIN RELTOL=1e-4 ABSTOL=1e-9
.OPTIONS TIMEINT METHOD=trap RELTOL=1e-3 ABSTOL=1e-12
.OPTIONS MEASURE MEASDGT=5
.param vdd_val = 0.40
VDD vdd 0 DC {vdd_val}
VSS vss 0 DC 0
VA0 in_a0 0 DC 0
VA1 in_a1 0 DC 0
VB in_b 0 PULSE(0 {vdd_val} 100p 10p 10p 390p 800p)
.include '/Users/bruce/CLAUDE/asap5/charflow/extraction/AOI21x1_slvt.spice'
X1 in_a0 in_a1 in_b out vdd vss AOI21x1_slvt
CLOAD out 0 1.0f
.TRAN 1p 1000p
.MEASURE TRAN tphl TRIG V(in_b) VAL={vdd_val*0.5} RISE=1 TARG V(out) VAL={vdd_val*0.5} FALL=1
.MEASURE TRAN tplh TRIG V(in_b) VAL={vdd_val*0.5} FALL=1 TARG V(out) VAL={vdd_val*0.5} RISE=1
.MEASURE TRAN avg_i AVG I(VDD) FROM=100p TO=500p
.MEASURE TRAN e_total INTEG I(VDD) FROM=100p TO=500p
.END
