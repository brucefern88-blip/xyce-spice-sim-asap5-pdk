.subckt XOR2x2 A B Y VDD VSS
* B inverter
mn_invb BB B VSS VSS nmos_lvt l=16n nfin=4
mp_invb BB B VDD VDD pmos_lvt l=16n nfin=4
* A inverter
mn_inva AB A VSS VSS nmos_lvt l=16n nfin=4
mp_inva AB A VDD VDD pmos_lvt l=16n nfin=4
* TG1: pass A when B=1 (N-gate=B, P-gate=BB)
mn_tg1 A B Y VSS nmos_lvt l=16n nfin=4
mp_tg1 A BB Y VDD pmos_lvt l=16n nfin=4
* TG2: pass ~A when B=0 (N-gate=BB, P-gate=B)
mn_tg2 AB BB Y VSS nmos_lvt l=16n nfin=4
mp_tg2 AB B Y VDD pmos_lvt l=16n nfin=4
Cext_Y Y 0 0.060f
Cext_A A 0 0.070f
Cext_B B 0 0.070f
Cext_BB BB 0 0.060f
Cext_AB AB 0 0.060f
.ends XOR2x2
