* MUX21x1 PPA characterization — 0.7V LVT
* Path: D1→Y with S=1 (TG1 active), D0=0
.include '/Users/bruce/CLAUDE/asap5/spice/xyce_models/nmos_lvt_tt_cal.pm'
.include '/Users/bruce/CLAUDE/asap5/spice/xyce_models/pmos_lvt_tt_cal.pm'

.OPTIONS DEVICE GMIN=1e-12
.OPTIONS NONLIN RELTOL=1e-4 ABSTOL=1e-9
.OPTIONS TIMEINT METHOD=trap RELTOL=1e-3 ABSTOL=1e-12
.OPTIONS MEASURE MEASDGT=5

.param vdd_val = 0.7
.param cload = 1f

VDD vdd 0 DC {vdd_val}
VSS vss 0 DC 0

VS in_s 0 DC {vdd_val}
VD0 in_d0 0 DC 0
VD1 in_d1 0 PULSE(0 {vdd_val} 50p 5p 5p 195p 400p)

.include '/Users/bruce/CLAUDE/asap5/charflow/extraction/MUX21x1.spice'
X1 in_d0 in_d1 in_s out vdd vss MUX21x1

CLOAD out 0 {cload}

.TRAN 0.5p 400p

* Delay measurements (50% thresholds)
.MEASURE TRAN tphl TRIG V(in_d1) VAL={vdd_val*0.5} RISE=1
+                   TARG V(out) VAL={vdd_val*0.5} FALL=1
.MEASURE TRAN tplh TRIG V(in_d1) VAL={vdd_val*0.5} FALL=1
+                   TARG V(out) VAL={vdd_val*0.5} RISE=1
.MEASURE TRAN tpd PARAM={(tphl+tplh)/2}

* Transition measurements (20%-80%)
.MEASURE TRAN fall_trans TRIG V(out) VAL={vdd_val*0.8} FALL=1
+                        TARG V(out) VAL={vdd_val*0.2} FALL=1
.MEASURE TRAN rise_trans TRIG V(out) VAL={vdd_val*0.2} RISE=1
+                        TARG V(out) VAL={vdd_val*0.8} RISE=1

* Energy: integrate supply current over one full cycle
.MEASURE TRAN q_fall INTEG I(VDD) FROM=50p TO=250p
.MEASURE TRAN q_rise INTEG I(VDD) FROM=250p TO=400p
.MEASURE TRAN q_cycle INTEG I(VDD) FROM=50p TO=400p
.MEASURE TRAN e_cycle PARAM={abs(q_cycle)*vdd_val}

.END
