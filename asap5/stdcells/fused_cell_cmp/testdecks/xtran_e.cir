* FUSED_E Transient Delay — Xyce BSIM-CMG post-layout
.include '/Users/bruce/CLAUDE/asap5/spice/xyce_models/nmos_slvt_tt_cal.pm'
.include '/Users/bruce/CLAUDE/asap5/spice/xyce_models/pmos_slvt_tt_cal.pm'
.OPTIONS DEVICE GMIN=1e-12
.OPTIONS NONLIN RELTOL=1e-4 ABSTOL=1e-9
.OPTIONS TIMEINT METHOD=trap RELTOL=1e-3 ABSTOL=1e-12
.OPTIONS MEASURE MEASDGT=6

Vvdd VDD 0 0.5
Vgnd VSS 0 0
Vai ai 0 DC 0
Vbi bi 0 PWL(0 0 200p 0 205p 0.5)
Vaj aj 0 DC 0
Vbj bj 0 DC 0

M1000 a_294_85# a_278_85# VDD w_0_65# pmos_slvt l=16n nfin=2
M1001 VSS VSS a_118_225# Gnd nmos_slvt l=16n nfin=2
M1002 VSS a_14_205# a_0_150# Gnd nmos_slvt l=16n nfin=2
M1003 VDD a_322_85# a_294_85# w_0_65# pmos_slvt l=16n nfin=2
M1004 VSS ai VSS Gnd nmos_slvt l=16n nfin=2
M1005 VSS ai a_206_10# Gnd nmos_slvt l=16n nfin=2
M1006 VDD a_234_145# a_206_150# w_0_65# pmos_slvt l=16n nfin=2
M1007 a_206_150# a_190_145# VDD w_0_65# pmos_slvt l=16n nfin=2
M1008 VSS ai a_294_225# Gnd nmos_slvt l=16n nfin=2
M1009 a_118_85# a_102_85# VSS w_0_65# pmos_slvt l=16n nfin=2
M1010 VSS a_58_145# VDD w_0_65# pmos_slvt l=16n nfin=2
M1011 oh0 ai VSS Gnd nmos_slvt l=16n nfin=2
M1012 a_294_225# ai a_250_225# Gnd nmos_slvt l=16n nfin=2
M1013 a_426_150# a_410_145# a_382_150# w_0_65# pmos_slvt l=16n nfin=2
M1014 a_118_225# a_0_150# VSS Gnd nmos_slvt l=16n nfin=2
M1015 a_382_150# a_366_145# VDD w_0_65# pmos_slvt l=16n nfin=2
M1016 VSS a_58_85# VDD w_0_65# pmos_slvt l=16n nfin=2
M1017 VDD a_234_85# a_206_85# w_0_65# pmos_slvt l=16n nfin=2
M1018 VSS VSS a_118_10# Gnd nmos_slvt l=16n nfin=2
M1019 VDD a_146_145# a_118_150# w_0_65# pmos_slvt l=16n nfin=2
M1020 VSS a_14_5# VSS Gnd nmos_slvt l=16n nfin=2
M1021 a_206_10# a_190_5# VSS Gnd nmos_slvt l=16n nfin=2
M1022 VDD a_14_145# a_0_150# w_0_65# pmos_slvt l=16n nfin=2
M1023 a_250_225# ai a_206_225# Gnd nmos_slvt l=16n nfin=2
M1024 a_206_225# a_190_205# VSS Gnd nmos_slvt l=16n nfin=2
M1025 oh0 a_366_85# VDD w_0_65# pmos_slvt l=16n nfin=2
M1026 a_294_10# ai VSS Gnd nmos_slvt l=16n nfin=2
M1027 VDD a_322_145# VDD w_0_65# pmos_slvt l=16n nfin=2
M1028 VSS ai a_294_10# Gnd nmos_slvt l=16n nfin=2
M1029 VSS ai VSS Gnd nmos_slvt l=16n nfin=2
M1030 VSS ai oh1 Gnd nmos_slvt l=16n nfin=2
M1031 a_118_150# a_102_145# VSS w_0_65# pmos_slvt l=16n nfin=2
M1032 VDD a_278_145# VDD w_0_65# pmos_slvt l=16n nfin=2
M1033 VDD a_146_85# a_118_85# w_0_65# pmos_slvt l=16n nfin=2
M1034 VDD a_14_85# VSS w_0_65# pmos_slvt l=16n nfin=2
M1035 a_118_10# VSS VSS Gnd nmos_slvt l=16n nfin=2
M1036 oh1 ai VSS Gnd nmos_slvt l=16n nfin=2
M1037 a_206_85# a_190_85# VDD w_0_65# pmos_slvt l=16n nfin=2

CL_oh0 oh0 0 1f
CL_oh1 oh1 0 1f
CL_oh2 oh2 0 1f

.TRAN 0.5p 800p

.PRINT TRAN V(bi) V(oh0) V(oh1) V(oh2) I(Vvdd)

.MEASURE TRAN tpd_oh1 TRIG V(bi) VAL=0.25 RISE=1
+  TARG V(oh1) VAL=0.25 RISE=1
.MEASURE TRAN i_avg AVG I(Vvdd) FROM=0 TO=800p
.MEASURE TRAN i_switch AVG I(Vvdd) FROM=200p TO=600p
.END
