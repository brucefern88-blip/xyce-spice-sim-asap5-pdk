* =============================================================================
* run_G_ext_scaled_04v.cir — FUSED_G Schematic + Scaled Parasitic Caps, 0.40V
* =============================================================================
* 40T active-low fused Hamming cell (4 INV + 2 OAI22 + 2 INV + AOI22 + NAND2)
* Outputs: noh1 (hd=1, active-low), noh2 (hd=2, active-low)
* ASAP5 SLVT, nfin=2, VDD=0.40V
* Parasitic loading from FUSED_G_scaled.spice added as lumped output caps
* Run:  Xyce run_G_ext_scaled_04v.cir
* =============================================================================

.include '/Users/bruce/CLAUDE/asap5/spice/xyce_models/nmos_slvt_tt_cal.pm'
.include '/Users/bruce/CLAUDE/asap5/spice/xyce_models/pmos_slvt_tt_cal.pm'

.OPTIONS DEVICE GMIN=1e-12
.OPTIONS NONLIN RELTOL=1e-4 ABSTOL=1e-9
.OPTIONS TIMEINT METHOD=trap RELTOL=1e-3 ABSTOL=1e-12
.OPTIONS MEASURE MEASDGT=5

* --- Supply ---
Vvdd Vdd 0 0.40
Vgnd Gnd 0 0

* --- Stimulus: 4 input vectors sequentially ---
* 0-200ps:   ai=0 bi=0 aj=0 bj=0 -> hd=0 (noh1=1, noh2=1)
* 200-400ps: ai=1 bi=0 aj=0 bj=0 -> hd=1 (noh1=0, noh2=1)
* 400-600ps: ai=1 bi=0 aj=1 bj=0 -> hd=2 (noh1=1, noh2=0)
* 600-800ps: ai=0 bi=0 aj=1 bj=0 -> hd=1 (noh1=0, noh2=1)
Vin_ai ai 0 PWL(0 0 190p 0 200p 0.4 590p 0.4 600p 0 800p 0)
Vin_bi bi 0 DC 0
Vin_aj aj 0 PWL(0 0 390p 0 400p 0.4 800p 0.4)
Vin_bj bj 0 DC 0

* =============================================================================
* FUSED_G subcircuit — SLVT, nfin=2, VDD=0.40V
* =============================================================================
* --- Input inverters (8T) ---
Mn_iai nai ai Gnd Gnd nmos_slvt l=16n nfin=2
Mp_iai nai ai Vdd Vdd pmos_slvt l=16n nfin=2
Mn_ibi nbi bi Gnd Gnd nmos_slvt l=16n nfin=2
Mp_ibi nbi bi Vdd Vdd pmos_slvt l=16n nfin=2
Mn_iaj naj aj Gnd Gnd nmos_slvt l=16n nfin=2
Mp_iaj naj aj Vdd Vdd pmos_slvt l=16n nfin=2
Mn_ibj nbj bj Gnd Gnd nmos_slvt l=16n nfin=2
Mp_ibj nbj bj Vdd Vdd pmos_slvt l=16n nfin=2

* --- XOR0 via OAI22: x0 = ai^bi (8T) ---
Mp_q0_1 x0 nai q0pm1 Vdd pmos_slvt l=16n nfin=2
Mp_q0_2 q0pm1 nbi Vdd Vdd pmos_slvt l=16n nfin=2
Mp_q0_3 x0 ai q0pm2 Vdd pmos_slvt l=16n nfin=2
Mp_q0_4 q0pm2 bi Vdd Vdd pmos_slvt l=16n nfin=2
Mn_q0_1 q0nmid nai Gnd Gnd nmos_slvt l=16n nfin=2
Mn_q0_2 q0nmid nbi Gnd Gnd nmos_slvt l=16n nfin=2
Mn_q0_3 x0 ai q0nmid Gnd nmos_slvt l=16n nfin=2
Mn_q0_4 x0 bi q0nmid Gnd nmos_slvt l=16n nfin=2

* --- XOR1 via OAI22: x1 = aj^bj (8T) ---
Mp_q1_1 x1 naj q1pm1 Vdd pmos_slvt l=16n nfin=2
Mp_q1_2 q1pm1 nbj Vdd Vdd pmos_slvt l=16n nfin=2
Mp_q1_3 x1 aj q1pm2 Vdd pmos_slvt l=16n nfin=2
Mp_q1_4 q1pm2 bj Vdd Vdd pmos_slvt l=16n nfin=2
Mn_q1_1 q1nmid naj Gnd Gnd nmos_slvt l=16n nfin=2
Mn_q1_2 q1nmid nbj Gnd Gnd nmos_slvt l=16n nfin=2
Mn_q1_3 x1 aj q1nmid Gnd nmos_slvt l=16n nfin=2
Mn_q1_4 x1 bj q1nmid Gnd nmos_slvt l=16n nfin=2

* --- XOR output inverters (4T) ---
Mn_ix0 d0 x0 Gnd Gnd nmos_slvt l=16n nfin=2
Mp_ix0 d0 x0 Vdd Vdd pmos_slvt l=16n nfin=2
Mn_ix1 d1 x1 Gnd Gnd nmos_slvt l=16n nfin=2
Mp_ix1 d1 x1 Vdd Vdd pmos_slvt l=16n nfin=2

* --- nOH1: AOI22(d0,x1, x0,d1) — active-low (8T, no output INV) ---
Mp_a1_1 a1pm d0 Vdd Vdd pmos_slvt l=16n nfin=2
Mp_a1_2 a1pm x1 Vdd Vdd pmos_slvt l=16n nfin=2
Mp_a1_3 noh1 x0 a1pm Vdd pmos_slvt l=16n nfin=2
Mp_a1_4 noh1 d1 a1pm Vdd pmos_slvt l=16n nfin=2
Mn_a1_1 noh1 d0 a1nm1 Gnd nmos_slvt l=16n nfin=2
Mn_a1_2 a1nm1 x1 Gnd Gnd nmos_slvt l=16n nfin=2
Mn_a1_3 noh1 x0 a1nm2 Gnd nmos_slvt l=16n nfin=2
Mn_a1_4 a1nm2 d1 Gnd Gnd nmos_slvt l=16n nfin=2

* --- nOH2: NAND2(d0,d1) — active-low (4T) ---
Mp_n2_1 noh2 d0 Vdd Vdd pmos_slvt l=16n nfin=2
Mp_n2_2 noh2 d1 Vdd Vdd pmos_slvt l=16n nfin=2
Mn_n2_1 noh2 d0 n2ns Gnd nmos_slvt l=16n nfin=2
Mn_n2_2 n2ns d1 Gnd Gnd nmos_slvt l=16n nfin=2

* --- Output loads (1fF functional + extracted parasitic) ---
CL_noh1 noh1 0 1f
CL_noh2 noh2 0 1f

* --- Scaled parasitic caps from layout extraction ---
Cext_noh1 noh1 0 0.24f
Cext_noh2 noh2 0 0.36f

* =============================================================================
* Analysis
* =============================================================================
.TRAN 1p 800p

.PRINT TRAN V(ai) V(bi) V(aj) V(bj) V(noh1) V(noh2) I(Vvdd)

* --- nOH1 transitions (active-low: falls when hd=1, rises when hd!=1) ---
* t=200p: noh1 falls (hd=0->1), t=400p: noh1 rises (hd=1->2), t=600p: noh1 falls (hd=2->1)
.MEASURE TRAN tphl_noh1_1 TRIG V(ai) VAL=0.2 RISE=1 TARG V(noh1) VAL=0.2 FALL=1
.MEASURE TRAN tplh_noh1_1 TRIG V(aj) VAL=0.2 RISE=1 TARG V(noh1) VAL=0.2 RISE=1
.MEASURE TRAN tphl_noh1_2 TRIG V(ai) VAL=0.2 FALL=1 TARG V(noh1) VAL=0.2 FALL=2

* --- nOH2 transitions (active-low: falls when hd=2, rises when hd!=2) ---
* t=400p: noh2 falls (hd=1->2), t=600p: noh2 rises (hd=2->1)
.MEASURE TRAN tphl_noh2_1 TRIG V(aj) VAL=0.2 RISE=1 TARG V(noh2) VAL=0.2 FALL=1
.MEASURE TRAN tplh_noh2_1 TRIG V(ai) VAL=0.2 FALL=1 TARG V(noh2) VAL=0.2 RISE=1

* --- Steady-state verification ---
.MEASURE TRAN v_noh1_hd0 FIND V(noh1) AT=180p
.MEASURE TRAN v_noh2_hd0 FIND V(noh2) AT=180p
.MEASURE TRAN v_noh1_hd1a FIND V(noh1) AT=380p
.MEASURE TRAN v_noh2_hd1a FIND V(noh2) AT=380p
.MEASURE TRAN v_noh1_hd2 FIND V(noh1) AT=580p
.MEASURE TRAN v_noh2_hd2 FIND V(noh2) AT=580p
.MEASURE TRAN v_noh1_hd1b FIND V(noh1) AT=780p
.MEASURE TRAN v_noh2_hd1b FIND V(noh2) AT=780p

.MEASURE TRAN i_avg AVG I(Vvdd) FROM=0 TO=800p

.END
