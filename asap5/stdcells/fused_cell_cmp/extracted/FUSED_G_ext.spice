* NGSPICE file created from FUSED_G.ext - technology: asap5

.global Vdd Gnd

.subckt FUSED_G
M1000 a_294_85# a_278_85# a_266_10# w_0_65# pmos_slvt w=0.45u l=0.16u
+  ad=63f pd=0.73u as=54f ps=1.14u
M1001 VSS a_146_225# a_118_225# Gnd nmos_slvt w=0.45u l=0.16u
+  ad=54f pd=1.14u as=63f ps=0.73u
M1002 VSS a_14_225# a_0_150# Gnd nmos_slvt w=0.45u l=0.16u
+  ad=63f pd=0.73u as=63f ps=1.18u
M1003 VDD a_322_85# a_294_85# w_0_65# pmos_slvt w=0.45u l=0.16u
+  ad=54f pd=1.14u as=63f ps=0.73u
M1004 a_74_10# bi VSS Gnd nmos_slvt w=0.45u l=0.16u
+  ad=54f pd=1.14u as=63f ps=0.73u
M1005 VSS a_234_5# a_206_10# Gnd nmos_slvt w=0.45u l=0.16u
+  ad=54f pd=1.14u as=63f ps=0.73u
M1006 a_250_150# a_234_145# a_206_150# w_0_65# pmos_slvt w=0.45u l=0.16u
+  ad=54f pd=1.14u as=63f ps=0.73u
M1007 a_206_150# a_190_145# a_178_150# w_0_65# pmos_slvt w=0.45u l=0.16u
+  ad=63f pd=0.73u as=54f ps=1.14u
M1008 VSS a_322_225# a_294_225# Gnd nmos_slvt w=0.45u l=0.16u
+  ad=63f pd=1.18u as=63f ps=0.73u
M1009 VDD a_102_85# a_90_10# w_0_65# pmos_slvt w=0.45u l=0.16u
+  ad=63f pd=0.73u as=54f ps=1.14u
M1010 a_0_150# a_58_145# VDD w_0_65# pmos_slvt w=0.45u l=0.16u
+  ad=54f pd=1.14u as=63f ps=0.73u
M1011 a_470_85# a_454_85# a_266_10# w_0_65# pmos_slvt w=0.45u l=0.16u
+  ad=63f pd=0.73u as=54f ps=1.14u
M1012 a_382_10# a_366_5# VSS Gnd nmos_slvt w=0.45u l=0.16u
+  ad=63f pd=0.73u as=54f ps=1.14u
M1013 a_294_225# a_278_225# a_266_150# Gnd nmos_slvt w=0.45u l=0.16u
+  ad=63f pd=0.73u as=54f ps=1.14u
M1014 a_118_225# a_102_225# a_90_225# Gnd nmos_slvt w=0.45u l=0.16u
+  ad=63f pd=0.73u as=54f ps=1.14u
M1015 VSS a_410_5# a_382_10# Gnd nmos_slvt w=0.45u l=0.16u
+  ad=54f pd=1.14u as=63f ps=0.73u
M1016 a_74_10# a_58_85# VDD w_0_65# pmos_slvt w=0.45u l=0.16u
+  ad=54f pd=1.14u as=63f ps=0.73u
M1017 VDD a_234_85# a_206_85# w_0_65# pmos_slvt w=0.45u l=0.16u
+  ad=54f pd=1.14u as=63f ps=0.73u
M1018 a_74_10# bj VSS Gnd nmos_slvt w=0.45u l=0.16u
+  ad=54f pd=1.14u as=63f ps=0.73u
M1019 VDD a_146_145# a_118_150# w_0_65# pmos_slvt w=0.45u l=0.16u
+  ad=54f pd=1.14u as=63f ps=0.73u
M1020 a_514_10# a_498_5# a_470_10# Gnd nmos_slvt w=0.45u l=0.16u
+  ad=63f pd=1.18u as=63f ps=0.73u
M1021 VSS ai a_0_10# Gnd nmos_slvt w=0.45u l=0.16u
+  ad=63f pd=0.73u as=63f ps=1.18u
M1022 a_206_10# a_190_5# VSS Gnd nmos_slvt w=0.45u l=0.16u
+  ad=63f pd=0.73u as=54f ps=1.14u
M1023 VDD a_14_145# a_0_150# w_0_65# pmos_slvt w=0.45u l=0.16u
+  ad=63f pd=0.73u as=63f ps=1.18u
M1024 VSS a_234_225# a_206_225# Gnd nmos_slvt w=0.45u l=0.16u
+  ad=54f pd=1.14u as=63f ps=0.73u
M1025 a_206_225# a_190_225# a_178_150# Gnd nmos_slvt w=0.45u l=0.16u
+  ad=63f pd=0.73u as=54f ps=1.14u
M1026 a_382_85# a_366_85# a_354_85# w_0_65# pmos_slvt w=0.45u l=0.16u
+  ad=63f pd=0.73u as=54f ps=1.14u
M1027 a_294_10# a_278_5# a_266_10# Gnd nmos_slvt w=0.45u l=0.16u
+  ad=63f pd=0.73u as=54f ps=1.14u
M1028 a_338_150# a_322_145# VDD w_0_65# pmos_slvt w=0.45u l=0.16u
+  ad=63f pd=1.18u as=63f ps=0.73u
M1029 VDD a_410_85# a_382_85# w_0_65# pmos_slvt w=0.45u l=0.16u
+  ad=54f pd=1.14u as=63f ps=0.73u
M1030 a_338_10# a_322_5# a_294_10# Gnd nmos_slvt w=0.45u l=0.16u
+  ad=54f pd=1.14u as=63f ps=0.73u
M1031 a_0_150# a_58_225# VSS Gnd nmos_slvt w=0.45u l=0.16u
+  ad=54f pd=1.14u as=63f ps=0.73u
M1032 a_118_150# a_102_145# VDD w_0_65# pmos_slvt w=0.45u l=0.16u
+  ad=63f pd=0.73u as=54f ps=1.14u
M1033 VDD a_278_145# a_266_150# w_0_65# pmos_slvt w=0.45u l=0.16u
+  ad=63f pd=0.73u as=54f ps=1.14u
M1034 a_74_10# a_146_85# VDD w_0_65# pmos_slvt w=0.45u l=0.16u
+  ad=54f pd=1.14u as=63f ps=0.73u
M1035 VDD a_498_85# a_470_85# w_0_65# pmos_slvt w=0.45u l=0.16u
+  ad=63f pd=1.18u as=63f ps=0.73u
M1036 VDD a_14_85# a_0_10# w_0_65# pmos_slvt w=0.45u l=0.16u
+  ad=63f pd=0.73u as=63f ps=1.18u
M1037 VSS aj a_90_10# Gnd nmos_slvt w=0.45u l=0.16u
+  ad=63f pd=0.73u as=54f ps=1.14u
M1038 a_206_85# a_190_85# a_178_85# w_0_65# pmos_slvt w=0.45u l=0.16u
+  ad=63f pd=0.73u as=54f ps=1.14u
M1039 a_470_10# a_454_5# a_266_10# Gnd nmos_slvt w=0.45u l=0.16u
+  ad=63f pd=0.73u as=54f ps=1.14u
.ends
