* =============================================================================
* run_E_dc_04v.cir — FUSED_E DC VTC Sweep at SLVT 0.40V
* =============================================================================
* Sweep ai from 0 to 0.4V, bi=0, aj=0.4V, bj=0
* This gives: x0 = ai^bi = ai, x1 = aj^bj = 1
* hd transitions between 1 (ai=0) and 2 (ai=1)
* Measure v_trip on oh1
* =============================================================================

.include '/Users/bruce/CLAUDE/asap5/spice/xyce_models/nmos_slvt_tt_cal.pm'
.include '/Users/bruce/CLAUDE/asap5/spice/xyce_models/pmos_slvt_tt_cal.pm'

.OPTIONS DEVICE GMIN=1e-12
.OPTIONS NONLIN RELTOL=1e-4 ABSTOL=1e-9
.OPTIONS MEASURE MEASDGT=5

* --- Supply ---
Vvdd Vdd 0 0.40
Vgnd Gnd 0 0

* --- Stimulus ---
Vin_ai ai 0 DC 0
Vin_bi bi 0 DC 0
Vin_aj aj 0 DC 0.40
Vin_bj bj 0 DC 0

* =============================================================================
* FUSED_E subcircuit — SLVT, nfin=2
* =============================================================================
* --- Input inverters (8T) ---
Mn_iai nai ai Gnd Gnd nmos_slvt l=16n nfin=2
Mp_iai nai ai Vdd Vdd pmos_slvt l=16n nfin=2
Mn_ibi nbi bi Gnd Gnd nmos_slvt l=16n nfin=2
Mp_ibi nbi bi Vdd Vdd pmos_slvt l=16n nfin=2
Mn_iaj naj aj Gnd Gnd nmos_slvt l=16n nfin=2
Mp_iaj naj aj Vdd Vdd pmos_slvt l=16n nfin=2
Mn_ibj nbj bj Gnd Gnd nmos_slvt l=16n nfin=2
Mp_ibj nbj bj Vdd Vdd pmos_slvt l=16n nfin=2

* --- XOR0 via OAI22: x0 = ai^bi (8T) ---
Mp_q0_1 x0 nai q0pm1 Vdd pmos_slvt l=16n nfin=2
Mp_q0_2 q0pm1 nbi Vdd Vdd pmos_slvt l=16n nfin=2
Mp_q0_3 x0 ai q0pm2 Vdd pmos_slvt l=16n nfin=2
Mp_q0_4 q0pm2 bi Vdd Vdd pmos_slvt l=16n nfin=2
Mn_q0_1 q0nmid nai Gnd Gnd nmos_slvt l=16n nfin=2
Mn_q0_2 q0nmid nbi Gnd Gnd nmos_slvt l=16n nfin=2
Mn_q0_3 x0 ai q0nmid Gnd nmos_slvt l=16n nfin=2
Mn_q0_4 x0 bi q0nmid Gnd nmos_slvt l=16n nfin=2

* --- XOR1 via OAI22: x1 = aj^bj (8T) ---
Mp_q1_1 x1 naj q1pm1 Vdd pmos_slvt l=16n nfin=2
Mp_q1_2 q1pm1 nbj Vdd Vdd pmos_slvt l=16n nfin=2
Mp_q1_3 x1 aj q1pm2 Vdd pmos_slvt l=16n nfin=2
Mp_q1_4 q1pm2 bj Vdd Vdd pmos_slvt l=16n nfin=2
Mn_q1_1 q1nmid naj Gnd Gnd nmos_slvt l=16n nfin=2
Mn_q1_2 q1nmid nbj Gnd Gnd nmos_slvt l=16n nfin=2
Mn_q1_3 x1 aj q1nmid Gnd nmos_slvt l=16n nfin=2
Mn_q1_4 x1 bj q1nmid Gnd nmos_slvt l=16n nfin=2

* --- OH2: NOR2(x0,x1) (4T) ---
Mp_o2_1 o2ps x0 Vdd Vdd pmos_slvt l=16n nfin=2
Mp_o2_2 oh2 x1 o2ps Vdd pmos_slvt l=16n nfin=2
Mn_o2_1 oh2 x0 Gnd Gnd nmos_slvt l=16n nfin=2
Mn_o2_2 oh2 x1 Gnd Gnd nmos_slvt l=16n nfin=2

* --- OH0: NAND2(x0,x1) via NOR+INV (6T) ---
Mp_n0_1 no0 x0 Vdd Vdd pmos_slvt l=16n nfin=2
Mp_n0_2 no0 x1 Vdd Vdd pmos_slvt l=16n nfin=2
Mn_n0_1 no0 x0 n0ns Gnd nmos_slvt l=16n nfin=2
Mn_n0_2 n0ns x1 Gnd Gnd nmos_slvt l=16n nfin=2
Mn_io0 oh0 no0 Gnd Gnd nmos_slvt l=16n nfin=2
Mp_io0 oh0 no0 Vdd Vdd pmos_slvt l=16n nfin=2

* --- OH1: NOR2(oh0,oh2) (4T) ---
Mp_o1_1 o1ps oh0 Vdd Vdd pmos_slvt l=16n nfin=2
Mp_o1_2 oh1 oh2 o1ps Vdd pmos_slvt l=16n nfin=2
Mn_o1_1 oh1 oh0 Gnd Gnd nmos_slvt l=16n nfin=2
Mn_o1_2 oh1 oh2 Gnd Gnd nmos_slvt l=16n nfin=2

* =============================================================================
* DC sweep
* =============================================================================
.DC Vin_ai 0 0.4 0.001

.PRINT DC V(ai) V(oh0) V(oh1) V(oh2)

.MEASURE DC v_trip_oh1 WHEN V(oh1)=0.2 CROSS=1

.END
