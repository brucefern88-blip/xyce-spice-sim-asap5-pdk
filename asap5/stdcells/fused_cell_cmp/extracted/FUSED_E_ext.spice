* NGSPICE file created from FUSED_E.ext - technology: asap5

.global Vdd Gnd

.subckt FUSED_E
M1000 a_294_85# a_278_85# VDD w_0_65# pmos_slvt w=0.45u l=0.16u
+  ad=63f pd=0.73u as=63f ps=0.73u
M1001 VSS VSS a_118_225# Gnd nmos_slvt w=0.45u l=0.16u
+  ad=63f pd=0.73u as=63f ps=0.73u
M1002 VSS a_14_205# a_0_150# Gnd nmos_slvt w=0.45u l=0.16u
+  ad=63f pd=0.73u as=63f ps=1.18u
M1003 VDD a_322_85# a_294_85# w_0_65# pmos_slvt w=0.45u l=0.16u
+  ad=63f pd=0.73u as=63f ps=0.73u
M1004 VSS ai VSS Gnd nmos_slvt w=0.45u l=0.16u
+  ad=63f pd=0.73u as=1.26p ps=15.5u
M1005 VSS ai a_206_10# Gnd nmos_slvt w=0.45u l=0.16u
+  ad=63f pd=0.73u as=63f ps=0.73u
M1006 VDD a_234_145# a_206_150# w_0_65# pmos_slvt w=0.45u l=0.16u
+  ad=63f pd=0.73u as=63f ps=0.73u
M1007 a_206_150# a_190_145# VDD w_0_65# pmos_slvt w=0.45u l=0.16u
+  ad=63f pd=0.73u as=63f ps=0.73u
M1008 VSS ai a_294_225# Gnd nmos_slvt w=0.45u l=0.16u
+  ad=63f pd=0.73u as=63f ps=0.73u
M1009 a_118_85# a_102_85# VSS w_0_65# pmos_slvt w=0.45u l=0.16u
+  ad=63f pd=0.73u as=63f ps=0.73u
M1010 VSS a_58_145# VDD w_0_65# pmos_slvt w=0.45u l=0.16u
+  ad=63f pd=0.73u as=63f ps=0.73u
M1011 oh0 ai VSS Gnd nmos_slvt w=0.45u l=0.16u
+  ad=63f pd=1.18u as=63f ps=0.73u
M1012 a_294_225# ai a_250_225# Gnd nmos_slvt w=0.45u l=0.16u
+  ad=63f pd=0.73u as=63f ps=0.73u
M1013 a_426_150# a_410_145# a_382_150# w_0_65# pmos_slvt w=0.45u l=0.16u
+  ad=63f pd=1.18u as=63f ps=0.73u
M1014 a_118_225# a_0_150# VSS Gnd nmos_slvt w=0.45u l=0.16u
+  ad=63f pd=0.73u as=63f ps=0.73u
M1015 a_382_150# a_366_145# VDD w_0_65# pmos_slvt w=0.45u l=0.16u
+  ad=63f pd=0.73u as=63f ps=0.73u
M1016 VSS a_58_85# VDD w_0_65# pmos_slvt w=0.45u l=0.16u
+  ad=63f pd=0.73u as=63f ps=0.73u
M1017 VDD a_234_85# a_206_85# w_0_65# pmos_slvt w=0.45u l=0.16u
+  ad=63f pd=0.73u as=63f ps=0.73u
M1018 VSS VSS a_118_10# Gnd nmos_slvt w=0.45u l=0.16u
+  ad=63f pd=0.73u as=63f ps=0.73u
M1019 VDD a_146_145# a_118_150# w_0_65# pmos_slvt w=0.45u l=0.16u
+  ad=63f pd=0.73u as=63f ps=0.73u
M1020 VSS a_14_5# VSS Gnd nmos_slvt w=0.45u l=0.16u
+  ad=63f pd=1.18u as=0 ps=0
M1021 a_206_10# a_190_5# VSS Gnd nmos_slvt w=0.45u l=0.16u
+  ad=63f pd=0.73u as=63f ps=0.73u
M1022 VDD a_14_145# a_0_150# w_0_65# pmos_slvt w=0.45u l=0.16u
+  ad=63f pd=0.73u as=63f ps=1.18u
M1023 a_250_225# ai a_206_225# Gnd nmos_slvt w=0.45u l=0.16u
+  ad=63f pd=0.73u as=63f ps=0.73u
M1024 a_206_225# a_190_205# VSS Gnd nmos_slvt w=0.45u l=0.16u
+  ad=63f pd=0.73u as=63f ps=0.73u
M1025 oh0 a_366_85# VDD w_0_65# pmos_slvt w=0.45u l=0.16u
+  ad=63f pd=1.18u as=63f ps=0.73u
M1026 a_294_10# ai VSS Gnd nmos_slvt w=0.45u l=0.16u
+  ad=63f pd=0.73u as=63f ps=0.73u
M1027 VDD a_322_145# VDD w_0_65# pmos_slvt w=0.45u l=0.16u
+  ad=63f pd=0.73u as=1.134p ps=13.14u
M1028 VSS ai a_294_10# Gnd nmos_slvt w=0.45u l=0.16u
+  ad=63f pd=0.73u as=63f ps=0.73u
M1029 VSS ai VSS Gnd nmos_slvt w=0.45u l=0.16u
+  ad=63f pd=0.73u as=0 ps=0
M1030 VSS ai oh1 Gnd nmos_slvt w=0.45u l=0.16u
+  ad=63f pd=1.18u as=63f ps=0.73u
M1031 a_118_150# a_102_145# VSS w_0_65# pmos_slvt w=0.45u l=0.16u
+  ad=63f pd=0.73u as=63f ps=0.73u
M1032 VDD a_278_145# VDD w_0_65# pmos_slvt w=0.45u l=0.16u
+  ad=63f pd=0.73u as=0 ps=0
M1033 VDD a_146_85# a_118_85# w_0_65# pmos_slvt w=0.45u l=0.16u
+  ad=63f pd=0.73u as=63f ps=0.73u
M1034 VDD a_14_85# VSS w_0_65# pmos_slvt w=0.45u l=0.16u
+  ad=63f pd=0.73u as=63f ps=1.18u
M1035 a_118_10# VSS VSS Gnd nmos_slvt w=0.45u l=0.16u
+  ad=63f pd=0.73u as=63f ps=0.73u
M1036 oh1 ai VSS Gnd nmos_slvt w=0.45u l=0.16u
+  ad=63f pd=0.73u as=63f ps=0.73u
M1037 a_206_85# a_190_85# VDD w_0_65# pmos_slvt w=0.45u l=0.16u
+  ad=63f pd=0.73u as=63f ps=0.73u
.ends
