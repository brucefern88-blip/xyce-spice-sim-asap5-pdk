* =============================================================================
* run_G_dc_04v.cir — FUSED_G DC VTC Sweep at SLVT 0.40V
* =============================================================================
* Sweep ai from 0 to 0.4V, bi=0, aj=0.4V, bj=0
* This gives: x0 = ai^bi = ai, x1 = aj^bj = 1
* hd transitions between 1 (ai=0) and 2 (ai=1)
* Measure v_trip on noh1 (active-low hd=1 output)
* =============================================================================

.include '/Users/bruce/CLAUDE/asap5/spice/xyce_models/nmos_slvt_tt_cal.pm'
.include '/Users/bruce/CLAUDE/asap5/spice/xyce_models/pmos_slvt_tt_cal.pm'

.OPTIONS DEVICE GMIN=1e-12
.OPTIONS NONLIN RELTOL=1e-4 ABSTOL=1e-9
.OPTIONS MEASURE MEASDGT=5

* --- Supply ---
Vvdd Vdd 0 0.40
Vgnd Gnd 0 0

* --- Stimulus ---
Vin_ai ai 0 DC 0
Vin_bi bi 0 DC 0
Vin_aj aj 0 DC 0.40
Vin_bj bj 0 DC 0

* =============================================================================
* FUSED_G subcircuit — SLVT, nfin=2
* =============================================================================
* --- Input inverters (8T) ---
Mn_iai nai ai Gnd Gnd nmos_slvt l=16n nfin=2
Mp_iai nai ai Vdd Vdd pmos_slvt l=16n nfin=2
Mn_ibi nbi bi Gnd Gnd nmos_slvt l=16n nfin=2
Mp_ibi nbi bi Vdd Vdd pmos_slvt l=16n nfin=2
Mn_iaj naj aj Gnd Gnd nmos_slvt l=16n nfin=2
Mp_iaj naj aj Vdd Vdd pmos_slvt l=16n nfin=2
Mn_ibj nbj bj Gnd Gnd nmos_slvt l=16n nfin=2
Mp_ibj nbj bj Vdd Vdd pmos_slvt l=16n nfin=2

* --- XOR0 via OAI22: x0 = ai^bi (8T) ---
Mp_q0_1 x0 nai q0pm1 Vdd pmos_slvt l=16n nfin=2
Mp_q0_2 q0pm1 nbi Vdd Vdd pmos_slvt l=16n nfin=2
Mp_q0_3 x0 ai q0pm2 Vdd pmos_slvt l=16n nfin=2
Mp_q0_4 q0pm2 bi Vdd Vdd pmos_slvt l=16n nfin=2
Mn_q0_1 q0nmid nai Gnd Gnd nmos_slvt l=16n nfin=2
Mn_q0_2 q0nmid nbi Gnd Gnd nmos_slvt l=16n nfin=2
Mn_q0_3 x0 ai q0nmid Gnd nmos_slvt l=16n nfin=2
Mn_q0_4 x0 bi q0nmid Gnd nmos_slvt l=16n nfin=2

* --- XOR1 via OAI22: x1 = aj^bj (8T) ---
Mp_q1_1 x1 naj q1pm1 Vdd pmos_slvt l=16n nfin=2
Mp_q1_2 q1pm1 nbj Vdd Vdd pmos_slvt l=16n nfin=2
Mp_q1_3 x1 aj q1pm2 Vdd pmos_slvt l=16n nfin=2
Mp_q1_4 q1pm2 bj Vdd Vdd pmos_slvt l=16n nfin=2
Mn_q1_1 q1nmid naj Gnd Gnd nmos_slvt l=16n nfin=2
Mn_q1_2 q1nmid nbj Gnd Gnd nmos_slvt l=16n nfin=2
Mn_q1_3 x1 aj q1nmid Gnd nmos_slvt l=16n nfin=2
Mn_q1_4 x1 bj q1nmid Gnd nmos_slvt l=16n nfin=2

* --- XOR output inverters (4T) ---
Mn_ix0 d0 x0 Gnd Gnd nmos_slvt l=16n nfin=2
Mp_ix0 d0 x0 Vdd Vdd pmos_slvt l=16n nfin=2
Mn_ix1 d1 x1 Gnd Gnd nmos_slvt l=16n nfin=2
Mp_ix1 d1 x1 Vdd Vdd pmos_slvt l=16n nfin=2

* --- nOH1: AOI22(d0,x1, x0,d1) — active-low (8T) ---
Mp_a1_1 a1pm d0 Vdd Vdd pmos_slvt l=16n nfin=2
Mp_a1_2 a1pm x1 Vdd Vdd pmos_slvt l=16n nfin=2
Mp_a1_3 noh1 x0 a1pm Vdd pmos_slvt l=16n nfin=2
Mp_a1_4 noh1 d1 a1pm Vdd pmos_slvt l=16n nfin=2
Mn_a1_1 noh1 d0 a1nm1 Gnd nmos_slvt l=16n nfin=2
Mn_a1_2 a1nm1 x1 Gnd Gnd nmos_slvt l=16n nfin=2
Mn_a1_3 noh1 x0 a1nm2 Gnd nmos_slvt l=16n nfin=2
Mn_a1_4 a1nm2 d1 Gnd Gnd nmos_slvt l=16n nfin=2

* --- nOH2: NAND2(d0,d1) — active-low (4T) ---
Mp_n2_1 noh2 d0 Vdd Vdd pmos_slvt l=16n nfin=2
Mp_n2_2 noh2 d1 Vdd Vdd pmos_slvt l=16n nfin=2
Mn_n2_1 noh2 d0 n2ns Gnd nmos_slvt l=16n nfin=2
Mn_n2_2 n2ns d1 Gnd Gnd nmos_slvt l=16n nfin=2

* =============================================================================
* DC sweep
* =============================================================================
.DC Vin_ai 0 0.4 0.001

.PRINT DC V(ai) V(noh1) V(noh2)

.MEASURE DC v_trip_noh1 WHEN V(noh1)=0.2 CROSS=1

.END
