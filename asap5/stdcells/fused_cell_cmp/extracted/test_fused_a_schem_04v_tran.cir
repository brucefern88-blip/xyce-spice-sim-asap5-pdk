* =============================================================================
* test_fused_a_schem_04v_tran.cir — FUSED_A Schematic-Level Transient VDD=0.40V SLVT
* =============================================================================
* ASAP5 GAA nanosheet SLVT TT calibrated models, BSIM-CMG level=107
* Schematic netlist from fused_cell_A.sp, converted for Xyce:
*   - Removed w= parameter (not used by BSIM-CMG)
*   - l=16n (physical gate length)
*   - nfin=2 on each MOSFET
*   - PMOS body terminal -> Vdd
*   - nmos_lvt -> nmos_slvt, pmos_lvt -> pmos_slvt
* Near-threshold operation: VDD=0.40V
* Reference simulation to compare against extracted layout.
* Run:  ~/xyce-stack/install/xyce/bin/Xyce test_fused_a_schem_04v_tran.cir
* =============================================================================

.include '/Users/bruce/CLAUDE/asap5/spice/xyce_models/nmos_slvt_tt_cal.pm'
.include '/Users/bruce/CLAUDE/asap5/spice/xyce_models/pmos_slvt_tt_cal.pm'

* --- Solver Options ---
.OPTIONS DEVICE GMIN=1e-10
.OPTIONS NONLIN RELTOL=1e-4 ABSTOL=1e-9 MAXSTEP=400
.OPTIONS TIMEINT METHOD=trap RELTOL=1e-3 ABSTOL=1e-12
.OPTIONS MEASURE MEASDGT=6

.param vdd_val = 0.40
.param half_vdd = 0.20

* =============================================================================
* FUSED_A schematic subcircuit (48T) — converted from fused_cell_A.sp
* Inputs: ai, bi, aj, bj   Outputs: oh0 (hd=0), oh1 (hd=1), oh2 (hd=2)
* =============================================================================
.subckt FUSED_A ai bi aj bj oh0 oh1 oh2 Vdd Gnd
* --- Input inverters ---
mn_iai nai ai Gnd Gnd nmos_slvt l=16n nfin=2
mp_iai nai ai Vdd Vdd pmos_slvt l=16n nfin=2
mn_ibi nbi bi Gnd Gnd nmos_slvt l=16n nfin=2
mp_ibi nbi bi Vdd Vdd pmos_slvt l=16n nfin=2
mn_iaj naj aj Gnd Gnd nmos_slvt l=16n nfin=2
mp_iaj naj aj Vdd Vdd pmos_slvt l=16n nfin=2
mn_ibj nbj bj Gnd Gnd nmos_slvt l=16n nfin=2
mp_ibj nbj bj Vdd Vdd pmos_slvt l=16n nfin=2
* --- XOR0: d0 = ai ^ bi (8T CMOS XOR) ---
mp_x0_1 x0pm ai Vdd Vdd pmos_slvt l=16n nfin=2
mp_x0_2 x0pm bi Vdd Vdd pmos_slvt l=16n nfin=2
mp_x0_3 d0 nai x0pm Vdd pmos_slvt l=16n nfin=2
mp_x0_4 d0 nbi x0pm Vdd pmos_slvt l=16n nfin=2
mn_x0_1 d0 ai x0nm1 Gnd nmos_slvt l=16n nfin=2
mn_x0_2 x0nm1 bi Gnd Gnd nmos_slvt l=16n nfin=2
mn_x0_3 d0 nai x0nm2 Gnd nmos_slvt l=16n nfin=2
mn_x0_4 x0nm2 nbi Gnd Gnd nmos_slvt l=16n nfin=2
* --- XOR1: d1 = aj ^ bj (8T CMOS XOR) ---
mp_x1_1 x1pm aj Vdd Vdd pmos_slvt l=16n nfin=2
mp_x1_2 x1pm bj Vdd Vdd pmos_slvt l=16n nfin=2
mp_x1_3 d1 naj x1pm Vdd pmos_slvt l=16n nfin=2
mp_x1_4 d1 nbj x1pm Vdd pmos_slvt l=16n nfin=2
mn_x1_1 d1 aj x1nm1 Gnd nmos_slvt l=16n nfin=2
mn_x1_2 x1nm1 bj Gnd Gnd nmos_slvt l=16n nfin=2
mn_x1_3 d1 naj x1nm2 Gnd nmos_slvt l=16n nfin=2
mn_x1_4 x1nm2 nbj Gnd Gnd nmos_slvt l=16n nfin=2
* --- XOR output inverters ---
mn_id0 xn0 d0 Gnd Gnd nmos_slvt l=16n nfin=2
mp_id0 xn0 d0 Vdd Vdd pmos_slvt l=16n nfin=2
mn_id1 xn1 d1 Gnd Gnd nmos_slvt l=16n nfin=2
mp_id1 xn1 d1 Vdd Vdd pmos_slvt l=16n nfin=2
* --- OH0: NOR2(d0,d1) + INV ---
mp_o0_1 o0ps d0 Vdd Vdd pmos_slvt l=16n nfin=2
mp_o0_2 oh0 d1 o0ps Vdd pmos_slvt l=16n nfin=2
mn_o0_1 oh0 d0 Gnd Gnd nmos_slvt l=16n nfin=2
mn_o0_2 oh0 d1 Gnd Gnd nmos_slvt l=16n nfin=2
* --- OH1: XOR(d0,d1) via AOI + INV ---
mp_a1_1 a1pm d0 Vdd Vdd pmos_slvt l=16n nfin=2
mp_a1_2 a1pm xn1 Vdd Vdd pmos_slvt l=16n nfin=2
mp_a1_3 no1 xn0 a1pm Vdd pmos_slvt l=16n nfin=2
mp_a1_4 no1 d1 a1pm Vdd pmos_slvt l=16n nfin=2
mn_a1_1 no1 d0 a1nm1 Gnd nmos_slvt l=16n nfin=2
mn_a1_2 a1nm1 xn1 Gnd Gnd nmos_slvt l=16n nfin=2
mn_a1_3 no1 xn0 a1nm2 Gnd nmos_slvt l=16n nfin=2
mn_a1_4 a1nm2 d1 Gnd Gnd nmos_slvt l=16n nfin=2
mn_io1 oh1 no1 Gnd Gnd nmos_slvt l=16n nfin=2
mp_io1 oh1 no1 Vdd Vdd pmos_slvt l=16n nfin=2
* --- OH2: NAND2(d0,d1) + INV ---
mp_n2_1 no2 d0 Vdd Vdd pmos_slvt l=16n nfin=2
mp_n2_2 no2 d1 Vdd Vdd pmos_slvt l=16n nfin=2
mn_n2_1 no2 d0 n2ns Gnd nmos_slvt l=16n nfin=2
mn_n2_2 n2ns d1 Gnd Gnd nmos_slvt l=16n nfin=2
mn_io2 oh2 no2 Gnd Gnd nmos_slvt l=16n nfin=2
mp_io2 oh2 no2 Vdd Vdd pmos_slvt l=16n nfin=2
.ends FUSED_A

* =============================================================================
* Testbench
* =============================================================================

* --- Supply ---
Vvdd VDD 0 {vdd_val}
Vgnd GND 0 0

* --- Input Stimuli ---
* Test vector: ai=pulse(0->0.4V), bi=0 DC, aj=0.4V DC, bj=0 DC
* Initial: ai=0 bi=0 aj=1 bj=0 => d0=0^0=0, d1=1^0=1 => hd=1 => oh1=H
* After ai pulse: ai=1 bi=0 aj=1 bj=0 => d0=1^0=1, d1=1^0=1 => hd=2 => oh2=H
* ai falls back: same as initial => hd=1 => oh1=H
Vai ai 0 PULSE(0 {vdd_val} 100p 10p 10p 190p 400p)
Vbi bi 0 0
Vaj aj 0 {vdd_val}
Vbj bj 0 0

* --- DUT ---
XDUT ai bi aj bj oh0 oh1 oh2 VDD GND FUSED_A

* --- Output Loads ---
CL_oh0 oh0 0 1f
CL_oh1 oh1 0 1f
CL_oh2 oh2 0 1f

* =============================================================================
* Analysis
* =============================================================================
.TRAN 1p 800p

.PRINT TRAN V(ai) V(bi) V(aj) V(bj) V(oh0) V(oh1) V(oh2) I(Vvdd)

* --- Propagation Delay: oh1 fall (hd 1->2 when ai rises at ~100p) ---
.MEASURE TRAN tphl_oh1 TRIG V(ai) VAL={half_vdd} RISE=1
+  TARG V(oh1) VAL={half_vdd} FALL=1

* --- Propagation Delay: oh1 rise (hd 2->1 when ai falls at ~300p) ---
.MEASURE TRAN tplh_oh1 TRIG V(ai) VAL={half_vdd} FALL=1
+  TARG V(oh1) VAL={half_vdd} RISE=1

* --- Propagation Delay: oh2 rise (hd 1->2 when ai rises at ~100p) ---
.MEASURE TRAN tplh_oh2 TRIG V(ai) VAL={half_vdd} RISE=1
+  TARG V(oh2) VAL={half_vdd} RISE=1

* --- Propagation Delay: oh2 fall (hd 2->1 when ai falls at ~300p) ---
.MEASURE TRAN tphl_oh2 TRIG V(ai) VAL={half_vdd} FALL=1
+  TARG V(oh2) VAL={half_vdd} FALL=1

* --- Propagation Delay: oh0 (should stay low throughout) ---
* oh0 goes high only when hd=0 (ai=bi AND aj=bj). Not tested in this vector.

* --- Average supply current over full sim ---
.MEASURE TRAN avg_idd AVG I(Vvdd) FROM=0 TO=800p

* --- Total energy ---
.MEASURE TRAN e_total INTEG I(Vvdd) FROM=0 TO=800p

.END
