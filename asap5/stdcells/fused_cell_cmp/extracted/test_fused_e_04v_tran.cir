* =============================================================================
* test_fused_e_04v_tran.cir — FUSED_E Post-Layout Transient at VDD=0.40V SLVT
* =============================================================================
* ASAP5 GAA nanosheet SLVT TT calibrated models, BSIM-CMG level=107
* Extracted layout from Magic, w= removed, l=16n, nfin=2
* Near-threshold operation: VDD=0.40V
*
* WARNING: Magic extraction shows equiv ai=bi=aj=bj=oh2 (all inputs + oh2
* shorted together in layout). The subcircuit therefore has only one
* effective input (ai) and two independent outputs (oh0, oh1).
*
* Run:  ~/xyce-stack/install/xyce/bin/Xyce -max-warnings 5 test_fused_e_04v_tran.cir
* =============================================================================

.include '/Users/bruce/CLAUDE/asap5/spice/xyce_models/nmos_slvt_tt_cal.pm'
.include '/Users/bruce/CLAUDE/asap5/spice/xyce_models/pmos_slvt_tt_cal.pm'

* --- Solver Options ---
.OPTIONS DEVICE GMIN=1e-12
.OPTIONS NONLIN RELTOL=1e-4 ABSTOL=1e-9
.OPTIONS TIMEINT METHOD=trap RELTOL=1e-3 ABSTOL=1e-12
.OPTIONS MEASURE MEASDGT=5

.param vdd_val = 0.40
.param half_vdd = 0.20

* =============================================================================
* Converted FUSED_E subcircuit from Magic extraction (FUSED_E_ext.spice)
* Conversion: removed w=, ad=, pd=, as=, ps=; l=16n; nfin=2;
*             PMOS body w_0_65# -> Vdd; NMOS body Gnd -> Gnd
* Note: ai=bi=aj=bj=oh2 shorted in layout (equiv in .ext)
* =============================================================================
.subckt FUSED_E ai oh0 oh1 Vdd Gnd

M1000 a_294_85# a_278_85# Vdd Vdd pmos_slvt l=16n nfin=2
M1001 Gnd Gnd a_118_225# Gnd nmos_slvt l=16n nfin=2
M1002 Gnd a_14_205# a_0_150# Gnd nmos_slvt l=16n nfin=2
M1003 Vdd a_322_85# a_294_85# Vdd pmos_slvt l=16n nfin=2
M1004 Gnd ai Gnd Gnd nmos_slvt l=16n nfin=2
M1005 Gnd ai a_206_10# Gnd nmos_slvt l=16n nfin=2
M1006 Vdd a_234_145# a_206_150# Vdd pmos_slvt l=16n nfin=2
M1007 a_206_150# a_190_145# Vdd Vdd pmos_slvt l=16n nfin=2
M1008 Gnd ai a_294_225# Gnd nmos_slvt l=16n nfin=2
M1009 a_118_85# a_102_85# Gnd Vdd pmos_slvt l=16n nfin=2
M1010 Gnd a_58_145# Vdd Vdd pmos_slvt l=16n nfin=2
M1011 oh0 ai Gnd Gnd nmos_slvt l=16n nfin=2
M1012 a_294_225# ai a_250_225# Gnd nmos_slvt l=16n nfin=2
M1013 a_426_150# a_410_145# a_382_150# Vdd pmos_slvt l=16n nfin=2
M1014 a_118_225# a_0_150# Gnd Gnd nmos_slvt l=16n nfin=2
M1015 a_382_150# a_366_145# Vdd Vdd pmos_slvt l=16n nfin=2
M1016 Gnd a_58_85# Vdd Vdd pmos_slvt l=16n nfin=2
M1017 Vdd a_234_85# a_206_85# Vdd pmos_slvt l=16n nfin=2
M1018 Gnd Gnd a_118_10# Gnd nmos_slvt l=16n nfin=2
M1019 Vdd a_146_145# a_118_150# Vdd pmos_slvt l=16n nfin=2
M1020 Gnd a_14_5# Gnd Gnd nmos_slvt l=16n nfin=2
M1021 a_206_10# a_190_5# Gnd Gnd nmos_slvt l=16n nfin=2
M1022 Vdd a_14_145# a_0_150# Vdd pmos_slvt l=16n nfin=2
M1023 a_250_225# ai a_206_225# Gnd nmos_slvt l=16n nfin=2
M1024 a_206_225# a_190_205# Gnd Gnd nmos_slvt l=16n nfin=2
M1025 oh0 a_366_85# Vdd Vdd pmos_slvt l=16n nfin=2
M1026 a_294_10# ai Gnd Gnd nmos_slvt l=16n nfin=2
M1027 Vdd a_322_145# Vdd Vdd pmos_slvt l=16n nfin=2
M1028 Gnd ai a_294_10# Gnd nmos_slvt l=16n nfin=2
M1029 Gnd ai Gnd Gnd nmos_slvt l=16n nfin=2
M1030 Gnd ai oh1 Gnd nmos_slvt l=16n nfin=2
M1031 a_118_150# a_102_145# Gnd Vdd pmos_slvt l=16n nfin=2
M1032 Vdd a_278_145# Vdd Vdd pmos_slvt l=16n nfin=2
M1033 Vdd a_146_85# a_118_85# Vdd pmos_slvt l=16n nfin=2
M1034 Vdd a_14_85# Gnd Vdd pmos_slvt l=16n nfin=2
M1035 a_118_10# Gnd Gnd Gnd nmos_slvt l=16n nfin=2
M1036 oh1 ai Gnd Gnd nmos_slvt l=16n nfin=2
M1037 a_206_85# a_190_85# Vdd Vdd pmos_slvt l=16n nfin=2

.ends FUSED_E

* =============================================================================
* Testbench
* =============================================================================

* --- Supply ---
Vvdd VDD 0 {vdd_val}
Vgnd GND 0 0

* --- Input Stimuli ---
* Due to extraction shorts (ai=bi=aj=bj=oh2), only one input drives the cell.
* Stimulus: ai toggles 0 -> VDD at 400p, then VDD -> 0 at 1200p
* This exercises both rising and falling transitions on the outputs.

Vai ai 0 PULSE(0 {vdd_val} 400p 5p 5p 800p 2000p)

* --- DUT ---
XDUT ai oh0 oh1 VDD GND FUSED_E

* --- Output Loads ---
CL_oh0 oh0 0 1f
CL_oh1 oh1 0 1f

* =============================================================================
* Analysis
* =============================================================================
.TRAN 0.5p 2000p

.PRINT TRAN V(ai) V(oh0) V(oh1) I(Vvdd)

* --- Propagation Delay: oh0 high-to-low (ai rises at 400p) ---
.MEASURE TRAN tphl TRIG V(ai) VAL={half_vdd} RISE=1
+  TARG V(oh0) VAL={half_vdd} FALL=1

* --- Propagation Delay: oh0 low-to-high (ai falls at 1200p) ---
.MEASURE TRAN tplh TRIG V(ai) VAL={half_vdd} FALL=1
+  TARG V(oh0) VAL={half_vdd} RISE=1

* --- Average supply current over full sim ---
.MEASURE TRAN avg_idd AVG I(Vvdd) FROM=0 TO=2000p

* --- Total energy (charge integral * VDD) ---
.MEASURE TRAN e_total INTEG I(Vvdd) FROM=0 TO=2000p

.END
