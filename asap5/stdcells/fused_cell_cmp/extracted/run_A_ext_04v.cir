* =============================================================================
* run_A_ext_04v.cir — FUSED_A Extracted Transient at SLVT 0.40V
* =============================================================================
* 48T canonical fused Hamming cell with layout parasitic capacitances
* from Magic extraction (FUSED_A.ext, scale 1000 1 1, cap in aF /1000 = fF)
* Outputs: oh0 (hd=0), oh1 (hd=1), oh2 (hd=2) — one-hot
* ASAP5 SLVT, nfin=2, VDD=0.40V
* Run:  Xyce run_A_ext_04v.cir
* =============================================================================

.include '/Users/bruce/CLAUDE/asap5/spice/xyce_models/nmos_slvt_tt_cal.pm'
.include '/Users/bruce/CLAUDE/asap5/spice/xyce_models/pmos_slvt_tt_cal.pm'

.OPTIONS DEVICE GMIN=1e-12
.OPTIONS NONLIN RELTOL=1e-4 ABSTOL=1e-9
.OPTIONS TIMEINT METHOD=trap RELTOL=1e-3 ABSTOL=1e-12
.OPTIONS MEASURE MEASDGT=5

* --- Supply ---
Vvdd Vdd 0 0.40
Vgnd Gnd 0 0

* --- Stimulus: 4 input vectors sequentially ---
* 0-200ps:   ai=0 bi=0 aj=0 bj=0 -> hd=0 (oh0=1, oh1=0, oh2=0)
* 200-400ps: ai=1 bi=0 aj=0 bj=0 -> hd=1 (oh0=0, oh1=1, oh2=0)
* 400-600ps: ai=1 bi=0 aj=1 bj=0 -> hd=2 (oh0=0, oh1=0, oh2=1)
* 600-800ps: ai=0 bi=0 aj=1 bj=0 -> hd=1 (oh0=0, oh1=1, oh2=0)
Vin_ai ai 0 PWL(0 0 190p 0 200p 0.4 590p 0.4 600p 0 800p 0)
Vin_bi bi 0 DC 0
Vin_aj aj 0 PWL(0 0 390p 0 400p 0.4 800p 0.4)
Vin_bj bj 0 DC 0

* =============================================================================
* FUSED_A subcircuit — SLVT, nfin=2, with layout parasitics
* =============================================================================
* --- Input inverters (8T) ---
Mn_iai nai ai Gnd Gnd nmos_slvt l=16n nfin=2
Mp_iai nai ai Vdd Vdd pmos_slvt l=16n nfin=2
Mn_ibi nbi bi Gnd Gnd nmos_slvt l=16n nfin=2
Mp_ibi nbi bi Vdd Vdd pmos_slvt l=16n nfin=2
Mn_iaj naj aj Gnd Gnd nmos_slvt l=16n nfin=2
Mp_iaj naj aj Vdd Vdd pmos_slvt l=16n nfin=2
Mn_ibj nbj bj Gnd Gnd nmos_slvt l=16n nfin=2
Mp_ibj nbj bj Vdd Vdd pmos_slvt l=16n nfin=2

* --- XOR0: d0 = ai ^ bi (8T CMOS XOR) ---
Mp_x0_1 x0pm ai Vdd Vdd pmos_slvt l=16n nfin=2
Mp_x0_2 x0pm bi Vdd Vdd pmos_slvt l=16n nfin=2
Mp_x0_3 d0 nai x0pm Vdd pmos_slvt l=16n nfin=2
Mp_x0_4 d0 nbi x0pm Vdd pmos_slvt l=16n nfin=2
Mn_x0_1 d0 ai x0nm1 Gnd nmos_slvt l=16n nfin=2
Mn_x0_2 x0nm1 bi Gnd Gnd nmos_slvt l=16n nfin=2
Mn_x0_3 d0 nai x0nm2 Gnd nmos_slvt l=16n nfin=2
Mn_x0_4 x0nm2 nbi Gnd Gnd nmos_slvt l=16n nfin=2

* --- XOR1: d1 = aj ^ bj (8T CMOS XOR) ---
Mp_x1_1 x1pm aj Vdd Vdd pmos_slvt l=16n nfin=2
Mp_x1_2 x1pm bj Vdd Vdd pmos_slvt l=16n nfin=2
Mp_x1_3 d1 naj x1pm Vdd pmos_slvt l=16n nfin=2
Mp_x1_4 d1 nbj x1pm Vdd pmos_slvt l=16n nfin=2
Mn_x1_1 d1 aj x1nm1 Gnd nmos_slvt l=16n nfin=2
Mn_x1_2 x1nm1 bj Gnd Gnd nmos_slvt l=16n nfin=2
Mn_x1_3 d1 naj x1nm2 Gnd nmos_slvt l=16n nfin=2
Mn_x1_4 x1nm2 nbj Gnd Gnd nmos_slvt l=16n nfin=2

* --- XOR output inverters (4T) ---
Mn_id0 xn0 d0 Gnd Gnd nmos_slvt l=16n nfin=2
Mp_id0 xn0 d0 Vdd Vdd pmos_slvt l=16n nfin=2
Mn_id1 xn1 d1 Gnd Gnd nmos_slvt l=16n nfin=2
Mp_id1 xn1 d1 Vdd Vdd pmos_slvt l=16n nfin=2

* --- OH0: NOR2(d0,d1) ---
Mp_o0_1 o0ps d0 Vdd Vdd pmos_slvt l=16n nfin=2
Mp_o0_2 oh0 d1 o0ps Vdd pmos_slvt l=16n nfin=2
Mn_o0_1 oh0 d0 Gnd Gnd nmos_slvt l=16n nfin=2
Mn_o0_2 oh0 d1 Gnd Gnd nmos_slvt l=16n nfin=2

* --- OH1: XOR(d0,d1) via AOI22 + INV ---
Mp_a1_1 a1pm d0 Vdd Vdd pmos_slvt l=16n nfin=2
Mp_a1_2 a1pm xn1 Vdd Vdd pmos_slvt l=16n nfin=2
Mp_a1_3 no1 xn0 a1pm Vdd pmos_slvt l=16n nfin=2
Mp_a1_4 no1 d1 a1pm Vdd pmos_slvt l=16n nfin=2
Mn_a1_1 no1 d0 a1nm1 Gnd nmos_slvt l=16n nfin=2
Mn_a1_2 a1nm1 xn1 Gnd Gnd nmos_slvt l=16n nfin=2
Mn_a1_3 no1 xn0 a1nm2 Gnd nmos_slvt l=16n nfin=2
Mn_a1_4 a1nm2 d1 Gnd Gnd nmos_slvt l=16n nfin=2
Mn_io1 oh1 no1 Gnd Gnd nmos_slvt l=16n nfin=2
Mp_io1 oh1 no1 Vdd Vdd pmos_slvt l=16n nfin=2

* --- OH2: NAND2(d0,d1) + INV ---
Mp_n2_1 no2 d0 Vdd Vdd pmos_slvt l=16n nfin=2
Mp_n2_2 no2 d1 Vdd Vdd pmos_slvt l=16n nfin=2
Mn_n2_1 no2 d0 n2ns Gnd nmos_slvt l=16n nfin=2
Mn_n2_2 n2ns d1 Gnd Gnd nmos_slvt l=16n nfin=2
Mn_io2 oh2 no2 Gnd Gnd nmos_slvt l=16n nfin=2
Mp_io2 oh2 no2 Vdd Vdd pmos_slvt l=16n nfin=2

* =============================================================================
* Layout parasitic capacitances from FUSED_A.ext
* Source: Magic extraction, ASAP5 tech, scale 1000 1 1
* Conversion: raw aF / 1000 = fF
* Substrate cap from node lines + coupling cap summed per node
* =============================================================================
* --- Input pin parasitics (gate cap of 2 transistors + routing) ---
Cpar_ai   ai   0  0.215f
Cpar_bi   bi   0  0.215f
Cpar_aj   aj   0  0.215f
Cpar_bj   bj   0  0.230f
* --- Input inverter outputs (M1 short wires, ~2 gate loads each) ---
Cpar_nai  nai  0  0.25f
Cpar_nbi  nbi  0  0.25f
Cpar_naj  naj  0  0.25f
Cpar_nbj  nbj  0  0.25f
* --- XOR intermediate nodes (internal stacks, M1 routing) ---
* d0 maps to a_30_10# region — major routing node connecting 14 devices
* Total extracted: 262.7 fF — dominated by coupling to all surrounding nets
* Use effective driven-node cap: substrate(19.5) + local coupling estimate
Cpar_d0   d0   0  7.0f
Cpar_d1   d1   0  7.0f
Cpar_x0pm x0pm 0  0.5f
Cpar_x1pm x1pm 0  0.5f
* --- XOR output inverter outputs ---
Cpar_xn0  xn0  0  0.4f
Cpar_xn1  xn1  0  0.4f
* --- AOI22 internal nodes ---
Cpar_no1  no1  0  5.6f
* --- NAND2 internal node ---
Cpar_no2  no2  0  3.5f
* --- Output node parasitics from extraction ---
* oh0: substrate=2184 + coupling=7053 = 9237 aF = 9.24 fF
Cpar_oh0  oh0  0  9.24f
* oh1: substrate=2188 + coupling=4735 = 6923 aF = 6.92 fF
Cpar_oh1  oh1  0  6.92f
* oh2: substrate=1903 + coupling=0 = 1903 aF = 1.90 fF
Cpar_oh2  oh2  0  1.90f

* --- Output loads (external) ---
CL_oh0 oh0 0 1f
CL_oh1 oh1 0 1f
CL_oh2 oh2 0 1f

* =============================================================================
* Analysis
* =============================================================================
.TRAN 1p 800p

.PRINT TRAN V(ai) V(bi) V(aj) V(bj) V(oh0) V(oh1) V(oh2) I(Vvdd)

* --- OH0 transitions ---
.MEASURE TRAN tphl_oh0_1 TRIG V(ai) VAL=0.2 RISE=1 TARG V(oh0) VAL=0.2 FALL=1
.MEASURE TRAN tplh_oh0_1 TRIG V(ai) VAL=0.2 FALL=1 TARG V(oh0) VAL=0.2 RISE=1

* --- OH1 transitions ---
.MEASURE TRAN tplh_oh1_1 TRIG V(ai) VAL=0.2 RISE=1 TARG V(oh1) VAL=0.2 RISE=1
.MEASURE TRAN tphl_oh1_1 TRIG V(aj) VAL=0.2 RISE=1 TARG V(oh1) VAL=0.2 FALL=1
.MEASURE TRAN tplh_oh1_2 TRIG V(ai) VAL=0.2 FALL=1 TARG V(oh1) VAL=0.2 RISE=2

* --- OH2 transitions ---
.MEASURE TRAN tplh_oh2_1 TRIG V(aj) VAL=0.2 RISE=1 TARG V(oh2) VAL=0.2 RISE=1
.MEASURE TRAN tphl_oh2_1 TRIG V(ai) VAL=0.2 FALL=1 TARG V(oh2) VAL=0.2 FALL=1

* --- Steady-state verification ---
.MEASURE TRAN v_oh0_hd0 FIND V(oh0) AT=180p
.MEASURE TRAN v_oh1_hd0 FIND V(oh1) AT=180p
.MEASURE TRAN v_oh2_hd0 FIND V(oh2) AT=180p
.MEASURE TRAN v_oh0_hd1a FIND V(oh0) AT=380p
.MEASURE TRAN v_oh1_hd1a FIND V(oh1) AT=380p
.MEASURE TRAN v_oh2_hd1a FIND V(oh2) AT=380p
.MEASURE TRAN v_oh0_hd2 FIND V(oh0) AT=580p
.MEASURE TRAN v_oh1_hd2 FIND V(oh1) AT=580p
.MEASURE TRAN v_oh2_hd2 FIND V(oh2) AT=580p
.MEASURE TRAN v_oh0_hd1b FIND V(oh0) AT=780p
.MEASURE TRAN v_oh1_hd1b FIND V(oh1) AT=780p
.MEASURE TRAN v_oh2_hd1b FIND V(oh2) AT=780p

.MEASURE TRAN i_avg AVG I(Vvdd) FROM=0 TO=800p

.END
