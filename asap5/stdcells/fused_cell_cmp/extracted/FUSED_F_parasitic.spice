* NGSPICE file created from FUSED_F.ext - technology: asap5

.option scale=10n

M1000 a_294_85# a_278_5# a_250_85# w_0_65# pmos_slvt w=45 l=16
+  ad=0.63n pd=73u as=0.63n ps=73u
M1001 a_162_225# a_146_145# a_118_225# Gnd nmos_slvt w=45 l=16
+  ad=0.54n pd=0.114m as=0.63n ps=73u
M1002 a_30_225# a_14_145# oh2 Gnd nmos_slvt w=45 l=16
+  ad=0.63n pd=73u as=0.63n ps=0.118m
M1003 a_338_85# a_322_5# a_294_85# w_0_65# pmos_slvt w=45 l=16
+  ad=0.54n pd=0.114m as=0.63n ps=73u
M1004 a_74_10# bi VSS Gnd nmos_slvt w=45 l=16
+  ad=0.63n pd=73u as=0.63n ps=73u
M1005 a_250_10# a_234_5# a_206_10# Gnd nmos_slvt w=45 l=16
+  ad=0.63n pd=73u as=0.63n ps=73u
M1006 a_250_150# a_234_145# a_206_150# w_0_65# pmos_slvt w=45 l=16
+  ad=0.63n pd=73u as=0.63n ps=73u
M1007 a_206_150# a_190_145# a_178_150# w_0_65# pmos_slvt w=45 l=16
+  ad=0.63n pd=73u as=0.54n ps=0.114m
M1008 a_338_225# a_322_145# a_294_225# Gnd nmos_slvt w=45 l=16
+  ad=0.54n pd=0.114m as=0.63n ps=73u
M1009 VDD aj a_74_10# w_0_65# pmos_slvt w=45 l=16
+  ad=0.63n pd=73u as=0.63n ps=73u
M1010 a_74_150# a_58_145# VDD w_0_65# pmos_slvt w=45 l=16
+  ad=0.63n pd=0.118m as=0.63n ps=73u
M1011 a_470_85# a_454_5# a_426_85# w_0_65# pmos_slvt w=45 l=16
+  ad=0.63n pd=73u as=0.63n ps=73u
M1012 a_382_10# a_366_5# a_354_10# Gnd nmos_slvt w=45 l=16
+  ad=0.63n pd=73u as=0.54n ps=0.114m
M1013 a_294_225# a_278_145# a_250_150# Gnd nmos_slvt w=45 l=16
+  ad=0.63n pd=73u as=0.63n ps=73u
M1014 a_118_225# a_102_145# a_90_150# Gnd nmos_slvt w=45 l=16
+  ad=0.63n pd=73u as=0.54n ps=0.114m
M1015 a_426_10# a_410_5# a_382_10# Gnd nmos_slvt w=45 l=16
+  ad=0.63n pd=73u as=0.63n ps=73u
M1016 oh1 a_366_145# a_354_150# w_0_65# pmos_slvt w=45 l=16
+  ad=0.63n pd=0.118m as=0.54n ps=0.114m
M1017 a_74_10# bi VDD w_0_65# pmos_slvt w=45 l=16
+  ad=0.63n pd=73u as=0.63n ps=73u
M1018 a_250_85# a_234_5# a_206_85# w_0_65# pmos_slvt w=45 l=16
+  ad=0.63n pd=73u as=0.63n ps=73u
M1019 a_162_10# bj VSS Gnd nmos_slvt w=45 l=16
+  ad=0.63n pd=0.118m as=0.63n ps=73u
M1020 a_162_150# a_146_145# a_118_150# w_0_65# pmos_slvt w=45 l=16
+  ad=0.54n pd=0.114m as=0.63n ps=73u
M1021 a_514_10# a_498_5# a_470_10# Gnd nmos_slvt w=45 l=16
+  ad=0.63n pd=0.118m as=0.63n ps=73u
M1022 VSS ai a_0_10# Gnd nmos_slvt w=45 l=16
+  ad=0.63n pd=73u as=0.63n ps=0.118m
M1023 a_206_10# a_190_5# a_178_10# Gnd nmos_slvt w=45 l=16
+  ad=0.63n pd=73u as=0.54n ps=0.114m
M1024 VDD a_14_145# oh2 w_0_65# pmos_slvt w=45 l=16
+  ad=0.63n pd=73u as=0.63n ps=0.118m
M1025 a_250_150# a_234_145# a_206_225# Gnd nmos_slvt w=45 l=16
+  ad=0.63n pd=73u as=0.63n ps=73u
M1026 a_206_225# a_190_145# a_178_150# Gnd nmos_slvt w=45 l=16
+  ad=0.63n pd=73u as=0.54n ps=0.114m
M1027 a_382_85# a_366_5# a_354_85# w_0_65# pmos_slvt w=45 l=16
+  ad=0.63n pd=73u as=0.54n ps=0.114m
M1028 a_294_10# a_278_5# a_250_10# Gnd nmos_slvt w=45 l=16
+  ad=0.63n pd=73u as=0.63n ps=73u
M1029 a_338_150# a_322_145# a_294_150# w_0_65# pmos_slvt w=45 l=16
+  ad=0.54n pd=0.114m as=0.63n ps=73u
M1030 a_426_85# a_410_5# a_382_85# w_0_65# pmos_slvt w=45 l=16
+  ad=0.63n pd=73u as=0.63n ps=73u
M1031 a_338_10# a_322_5# a_294_10# Gnd nmos_slvt w=45 l=16
+  ad=0.54n pd=0.114m as=0.63n ps=73u
M1032 a_74_150# a_58_145# a_30_225# Gnd nmos_slvt w=45 l=16
+  ad=0.63n pd=0.118m as=0.63n ps=73u
M1033 a_118_150# a_102_145# a_90_150# w_0_65# pmos_slvt w=45 l=16
+  ad=0.63n pd=73u as=0.54n ps=0.114m
M1034 a_294_150# a_278_145# a_250_150# w_0_65# pmos_slvt w=45 l=16
+  ad=0.63n pd=73u as=0.63n ps=73u
M1035 a_162_10# bj VDD w_0_65# pmos_slvt w=45 l=16
+  ad=0.63n pd=0.118m as=0.63n ps=73u
M1036 a_514_85# a_498_5# a_470_85# w_0_65# pmos_slvt w=45 l=16
+  ad=0.63n pd=0.118m as=0.63n ps=73u
M1037 VDD ai a_0_10# w_0_65# pmos_slvt w=45 l=16
+  ad=0.63n pd=73u as=0.63n ps=0.118m
M1038 VSS aj a_74_10# Gnd nmos_slvt w=45 l=16
+  ad=0.63n pd=73u as=0.63n ps=73u
M1039 oh1 a_366_145# a_354_225# Gnd nmos_slvt w=45 l=16
+  ad=0.63n pd=0.118m as=0.54n ps=0.114m
M1040 a_206_85# a_190_5# a_178_85# w_0_65# pmos_slvt w=45 l=16
+  ad=0.63n pd=73u as=0.54n ps=0.114m
M1041 a_470_10# a_454_5# a_426_10# Gnd nmos_slvt w=45 l=16
+  ad=0.63n pd=73u as=0.63n ps=73u
C0 a_294_85# m1_94_100# 7.03067f
C1 a_250_85# m1_168_110# 7.00413f
C2 oh2 a_178_150# 4.30902f
C3 VDD m1_168_110# 0.42975f
C4 a_58_145# oh2 3.23866f
C5 a_426_85# m1_168_110# 0.0465f
C6 m1_168_110# m2_254_30# 1.77064f
C7 a_90_150# m1_78_240# 2.34809f
C8 a_278_145# oh2 3.02529f
C9 oh2 a_206_150# 0.0148f
C10 a_250_150# m1_78_240# 7.04203f
C11 a_206_225# m1_182_250# 7.00413f
C12 a_162_10# m1_94_100# 2.93468f
C13 a_234_5# m1_6_24# 0.56801f
C14 oh2 a_74_150# 5.38442f
C15 a_250_150# m2_254_30# 2.65304f
C16 a_250_85# m2_254_30# 1.35927f
C17 a_338_85# m1_94_100# 2.345f
C18 a_294_85# m1_168_110# 7.00413f
C19 oh2 a_206_225# 0.01319f
C20 VDD m2_254_30# 3.1635f
C21 a_102_145# oh2 3.84f
C22 a_382_85# m2_430_30# 0.01133f
C23 VSS m1_6_24# 21.3804f
C24 oh2 oh1 2.94992f
C25 m1_168_110# m2_430_30# 0.05565f
C26 a_118_225# m1_78_240# 6.94884f
C27 a_410_5# m1_168_110# 0.56709f
C28 a_322_145# oh2 3.17057f
C29 a_294_225# m1_78_240# 7.03067f
C30 a_250_150# m1_182_250# 5.2531f
C31 a_178_85# m1_94_100# 2.34356f
C32 oh2 a_90_150# 4.30902f
C33 m1_78_240# m1_182_250# 0.06137f
C34 a_354_85# m1_94_100# 2.35467f
C35 a_338_85# m1_168_110# 2.33471f
C36 oh2 a_250_150# 2.37182f
C37 VDD m2_430_30# 3.1635f
C38 a_146_145# oh2 3.36f
C39 a_426_85# m2_430_30# 2.61397f
C40 a_178_10# m1_6_24# 4.69826f
C41 oh2 VDD 0.01579f
C42 oh2 m2_254_30# 2.29411f
C43 a_162_225# m1_78_240# 2.31628f
C44 a_366_145# oh2 3.17057f
C45 a_250_10# m2_254_30# 2.92103f
C46 a_294_225# m1_182_250# 7.00413f
C47 a_206_85# m1_94_100# 7.03067f
C48 a_178_85# m1_168_110# 2.33471f
C49 oh2 a_118_225# 0.01319f
C50 a_382_85# m1_94_100# 0.02436f
C51 a_354_85# m1_168_110# 2.33471f
C52 oh2 a_294_225# 0.01319f
C53 m1_6_24# m2_254_30# 0.03557f
C54 m1_94_100# m1_168_110# 0.02088f
C55 a_190_145# oh2 3.36f
C56 a_206_10# m1_6_24# 6.9977f
C57 oh2 a_118_150# 0.0148f
C58 oh2 m2_430_30# 2.14532f
C59 a_178_150# m1_78_240# 2.34809f
C60 a_410_5# m2_430_30# 0.01764f
C61 a_74_10# m1_6_24# 8.77039f
C62 a_338_225# m1_182_250# 2.30743f
C63 a_250_85# m1_94_100# 7.03067f
C64 a_206_85# m1_168_110# 7.00413f
C65 a_234_5# m2_254_30# 0.01764f
C66 a_426_10# m2_430_30# 2.92103f
C67 VDD m1_94_100# 6.94884f
C68 a_14_145# oh2 2.99063f
C69 a_382_85# m1_168_110# 6.96921f
C70 m1_94_100# m2_254_30# 1.77064f
C71 a_30_225# m1_182_250# 0.24308f
C72 a_74_150# m1_78_240# 0.58702f
C73 a_366_5# m1_94_100# 0.56719f
C74 a_206_150# m2_254_30# 0.0149f
C75 a_234_145# oh2 3.36f
C76 a_250_10# m1_6_24# 0.02287f
C77 a_206_225# m1_78_240# 7.03067f
C78 a_162_10# m1_6_24# 5.89642f
C79 a_190_5# m1_6_24# 0.56945f
C80 a_354_225# m1_182_250# 2.30743f
C81 m2_430_30# 0 24.4576f
C82 m2_254_30# 0 18.332f
C83 m1_168_110# 0 32.1688f
C84 m1_94_100# 0 33.5736f
C85 m1_6_24# 0 51.6323f
C86 m1_182_250# 0 25.6034f
C87 m1_78_240# 0 25.9646f
C88 a_514_10# 0 91.25f $ **FLOATING
C89 a_470_10# 0 0.16506p $ **FLOATING
C90 a_426_10# 0 0.16506p $ **FLOATING
C91 a_382_10# 0 0.16506p $ **FLOATING
C92 a_354_10# 0 79.42f $ **FLOATING
C93 a_338_10# 0 79.42f $ **FLOATING
C94 a_294_10# 0 0.16506p $ **FLOATING
C95 a_250_10# 0 0.16506p $ **FLOATING
C96 a_206_10# 0 0.16506p $ **FLOATING
C97 a_178_10# 0 79.42f $ **FLOATING
C98 VSS 0 0.66667p $ **FLOATING
C99 a_514_85# 0 91.25f $ **FLOATING
C100 a_470_85# 0 0.16506p $ **FLOATING
C101 a_426_85# 0 0.16506p $ **FLOATING
C102 a_382_85# 0 0.16506p $ **FLOATING
C103 a_354_85# 0 79.42f $ **FLOATING
C104 a_338_85# 0 79.42f $ **FLOATING
C105 a_294_85# 0 0.16506p $ **FLOATING
C106 a_250_85# 0 0.16506p $ **FLOATING
C107 a_206_85# 0 0.16506p $ **FLOATING
C108 a_178_85# 0 79.42f $ **FLOATING
C109 a_162_10# 0 0.20209p $ **FLOATING
C110 a_74_10# 0 0.36767p $ **FLOATING
C111 a_0_10# 0 0.20229p $ **FLOATING
C112 a_498_5# 0 50.3204f $ **FLOATING
C113 a_454_5# 0 50.2625f $ **FLOATING
C114 a_410_5# 0 49.0025f $ **FLOATING
C115 a_366_5# 0 49.104f $ **FLOATING
C116 a_322_5# 0 50.364f $ **FLOATING
C117 a_278_5# 0 50.364f $ **FLOATING
C118 a_234_5# 0 49.104f $ **FLOATING
C119 a_190_5# 0 49.104f $ **FLOATING
C120 bj 0 50.364f $ **FLOATING
C121 aj 0 50.364f $ **FLOATING
C122 bi 0 50.364f $ **FLOATING
C123 ai 0 50.422f $ **FLOATING
C124 a_354_150# 0 79.42f $ **FLOATING
C125 a_338_150# 0 79.42f $ **FLOATING
C126 a_294_150# 0 0.16506p $ **FLOATING
C127 a_206_150# 0 0.16506p $ **FLOATING
C128 a_162_150# 0 79.42f $ **FLOATING
C129 a_118_150# 0 0.16506p $ **FLOATING
C130 VDD 0 1.05653p $ **FLOATING
C131 oh1 0 0.20396p $ **FLOATING
C132 a_354_225# 0 79.42f $ **FLOATING
C133 a_338_225# 0 79.42f $ **FLOATING
C134 a_294_225# 0 0.16506p $ **FLOATING
C135 a_250_150# 0 0.34636p $ **FLOATING
C136 a_206_225# 0 0.16506p $ **FLOATING
C137 a_178_150# 0 0.17527p $ **FLOATING
C138 a_162_225# 0 79.42f $ **FLOATING
C139 a_118_225# 0 0.16506p $ **FLOATING
C140 a_90_150# 0 0.17677p $ **FLOATING
C141 a_74_150# 0 0.20238p $ **FLOATING
C142 a_30_225# 0 0.49843p $ **FLOATING
C143 oh2 0 0.31711p $ **FLOATING
C144 a_366_145# 0 50.422f $ **FLOATING
C145 a_322_145# 0 50.364f $ **FLOATING
C146 a_278_145# 0 49.104f $ **FLOATING
C147 a_234_145# 0 48.684f $ **FLOATING
C148 a_190_145# 0 49.104f $ **FLOATING
C149 a_146_145# 0 48.684f $ **FLOATING
C150 a_102_145# 0 49.104f $ **FLOATING
C151 a_58_145# 0 48.684f $ **FLOATING
C152 a_14_145# 0 49.162f $ **FLOATING
