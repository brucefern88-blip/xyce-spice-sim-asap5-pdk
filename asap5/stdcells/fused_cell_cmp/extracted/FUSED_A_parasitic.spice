* NGSPICE file created from FUSED_A.ext - technology: asap5

.option scale=10n

M1000 a_470_150# a_454_145# a_426_150# w_0_65# pmos_slvt w=45 l=16
+  ad=0.54n pd=0.114m as=0.63n ps=73u
M1001 a_294_85# a_278_85# a_266_10# w_0_65# pmos_slvt w=45 l=16
+  ad=0.63n pd=73u as=0.54n ps=0.114m
M1002 a_162_225# a_146_225# a_118_225# Gnd nmos_slvt w=45 l=16
+  ad=0.54n pd=0.114m as=0.63n ps=73u
M1003 a_30_10# a_14_225# a_0_225# Gnd nmos_slvt w=45 l=16
+  ad=0.63n pd=73u as=0.63n ps=0.118m
M1004 a_338_85# a_322_85# a_294_85# w_0_65# pmos_slvt w=45 l=16
+  ad=0.54n pd=0.114m as=0.63n ps=73u
M1005 a_74_10# bi a_30_10# Gnd nmos_slvt w=45 l=16
+  ad=0.63n pd=73u as=0.63n ps=73u
M1006 a_250_10# a_234_5# a_206_10# Gnd nmos_slvt w=45 l=16
+  ad=0.54n pd=0.114m as=0.63n ps=73u
M1007 a_250_150# a_234_145# a_206_150# w_0_65# pmos_slvt w=45 l=16
+  ad=0.54n pd=0.114m as=0.63n ps=73u
M1008 a_206_150# a_190_145# a_30_10# w_0_65# pmos_slvt w=45 l=16
+  ad=0.63n pd=73u as=0.54n ps=0.114m
M1009 oh2 a_498_225# a_486_225# Gnd nmos_slvt w=45 l=16
+  ad=0.63n pd=0.118m as=0.54n ps=0.114m
M1010 a_338_225# a_322_225# a_294_225# Gnd nmos_slvt w=45 l=16
+  ad=0.54n pd=0.114m as=0.63n ps=73u
M1011 a_30_10# a_102_85# a_74_10# w_0_65# pmos_slvt w=45 l=16
+  ad=0.63n pd=73u as=0.63n ps=73u
M1012 a_30_10# a_58_145# a_30_10# w_0_65# pmos_slvt w=45 l=16
+  ad=0.63n pd=73u as=4.86n ps=0.666m
M1013 a_470_85# a_454_85# a_442_10# w_0_65# pmos_slvt w=45 l=16
+  ad=0.63n pd=73u as=0.54n ps=0.114m
M1014 a_382_10# a_366_5# a_354_10# Gnd nmos_slvt w=45 l=16
+  ad=0.63n pd=73u as=0.54n ps=0.114m
M1015 a_294_225# a_278_225# a_266_150# Gnd nmos_slvt w=45 l=16
+  ad=0.63n pd=73u as=0.54n ps=0.114m
M1016 a_426_150# a_410_145# a_398_150# w_0_65# pmos_slvt w=45 l=16
+  ad=0.63n pd=73u as=0.54n ps=0.114m
M1017 a_118_225# a_102_225# oh0 Gnd nmos_slvt w=45 l=16
+  ad=0.63n pd=73u as=0.54n ps=0.114m
M1018 a_426_10# a_410_5# a_382_10# Gnd nmos_slvt w=45 l=16
+  ad=0.54n pd=0.114m as=0.63n ps=73u
M1019 oh1 a_366_145# a_354_150# w_0_65# pmos_slvt w=45 l=16
+  ad=0.54n pd=0.114m as=0.54n ps=0.114m
M1020 a_74_10# a_58_85# a_30_10# w_0_65# pmos_slvt w=45 l=16
+  ad=0.63n pd=73u as=0.63n ps=73u
M1021 a_250_85# a_234_85# a_206_85# w_0_65# pmos_slvt w=45 l=16
+  ad=0.54n pd=0.114m as=0.63n ps=73u
M1022 a_162_10# bj a_30_10# Gnd nmos_slvt w=45 l=16
+  ad=0.54n pd=0.114m as=0.63n ps=73u
M1023 a_470_225# a_454_225# a_426_225# Gnd nmos_slvt w=45 l=16
+  ad=0.54n pd=0.114m as=0.63n ps=73u
M1024 a_162_150# a_146_145# a_118_150# w_0_65# pmos_slvt w=45 l=16
+  ad=0.54n pd=0.114m as=0.63n ps=73u
M1025 a_514_10# a_498_5# a_470_10# Gnd nmos_slvt w=45 l=16
+  ad=0.63n pd=0.118m as=0.63n ps=73u
M1026 a_30_10# ai a_0_10# Gnd nmos_slvt w=45 l=16
+  ad=0.63n pd=73u as=0.63n ps=0.118m
M1027 a_206_10# a_190_5# a_178_10# Gnd nmos_slvt w=45 l=16
+  ad=0.63n pd=73u as=0.54n ps=0.114m
M1028 a_30_10# a_14_145# a_0_150# w_0_65# pmos_slvt w=45 l=16
+  ad=0.63n pd=73u as=0.63n ps=0.118m
M1029 a_250_225# a_234_225# a_206_225# Gnd nmos_slvt w=45 l=16
+  ad=0.54n pd=0.114m as=0.63n ps=73u
M1030 a_206_225# a_190_225# a_30_10# Gnd nmos_slvt w=45 l=16
+  ad=0.63n pd=73u as=0.54n ps=0.114m
M1031 a_382_85# a_366_85# a_354_10# w_0_65# pmos_slvt w=45 l=16
+  ad=0.63n pd=73u as=0.54n ps=0.114m
M1032 a_294_10# a_278_5# a_266_10# Gnd nmos_slvt w=45 l=16
+  ad=0.63n pd=73u as=0.54n ps=0.114m
M1033 oh2 a_498_145# a_486_150# w_0_65# pmos_slvt w=45 l=16
+  ad=0.63n pd=0.118m as=0.54n ps=0.114m
M1034 a_338_150# a_322_145# a_294_150# w_0_65# pmos_slvt w=45 l=16
+  ad=0.54n pd=0.114m as=0.63n ps=73u
M1035 a_426_85# a_410_85# a_382_85# w_0_65# pmos_slvt w=45 l=16
+  ad=0.54n pd=0.114m as=0.63n ps=73u
M1036 a_338_10# a_322_5# a_294_10# Gnd nmos_slvt w=45 l=16
+  ad=0.54n pd=0.114m as=0.63n ps=73u
M1037 a_30_10# a_58_225# a_30_10# Gnd nmos_slvt w=45 l=16
+  ad=0.63n pd=73u as=4.86n ps=0.666m
M1038 a_426_225# a_410_225# a_398_150# Gnd nmos_slvt w=45 l=16
+  ad=0.63n pd=73u as=0.54n ps=0.114m
M1039 a_118_150# a_102_145# oh0 w_0_65# pmos_slvt w=45 l=16
+  ad=0.63n pd=73u as=0.54n ps=0.114m
M1040 a_294_150# a_278_145# a_266_150# w_0_65# pmos_slvt w=45 l=16
+  ad=0.63n pd=73u as=0.54n ps=0.114m
M1041 a_162_10# a_146_85# a_30_10# w_0_65# pmos_slvt w=45 l=16
+  ad=0.54n pd=0.114m as=0.63n ps=73u
M1042 a_514_85# a_498_85# a_470_85# w_0_65# pmos_slvt w=45 l=16
+  ad=0.63n pd=0.118m as=0.63n ps=73u
M1043 a_30_10# a_14_85# a_0_85# w_0_65# pmos_slvt w=45 l=16
+  ad=0.63n pd=73u as=0.63n ps=0.118m
M1044 a_30_10# aj a_74_10# Gnd nmos_slvt w=45 l=16
+  ad=0.63n pd=73u as=0.63n ps=73u
M1045 oh1 a_366_225# a_354_225# Gnd nmos_slvt w=45 l=16
+  ad=0.54n pd=0.114m as=0.54n ps=0.114m
M1046 a_206_85# a_190_85# a_178_10# w_0_65# pmos_slvt w=45 l=16
+  ad=0.63n pd=73u as=0.54n ps=0.114m
M1047 a_470_10# a_454_5# a_442_10# Gnd nmos_slvt w=45 l=16
+  ad=0.63n pd=73u as=0.54n ps=0.114m
C0 a_30_10# a_442_10# 5.29108f
C1 a_30_10# a_338_10# 0.01169f
C2 a_426_225# m1_402_252# 6.80509f
C3 a_30_10# a_206_150# 0.10523f
C4 a_30_10# a_58_145# 1.58529f
C5 a_30_10# a_426_150# 6.98545f
C6 a_30_10# a_322_5# 0.0146f
C7 a_30_10# a_206_85# 17.5224f
C8 a_206_225# m1_182_242# 6.98013f
C9 a_30_10# VDD 17.5469f
C10 a_30_10# a_162_225# 6.14007f
C11 a_30_10# a_278_145# 3.17057f
C12 a_354_225# m1_182_242# 2.32233f
C13 a_30_10# a_470_85# 6.91028f
C14 a_30_10# a_382_10# 7.08822f
C15 a_470_225# m1_402_252# 2.26836f
C16 a_30_10# a_250_150# 0.02966f
C17 a_30_10# bj 0.0146f
C18 a_30_10# m1_182_242# 0.0286f
C19 a_30_10# a_102_145# 1.58529f
C20 a_30_10# a_366_5# 0.05679f
C21 a_30_10# a_250_85# 5.83862f
C22 m1_402_252# VSS 0.17261f
C23 a_30_10# VSS 0.06959f
C24 a_250_225# m1_182_242# 2.32233f
C25 a_30_10# a_206_225# 1.6404f
C26 a_30_10# a_322_145# 1.58622f
C27 a_30_10# a_354_10# 23.2248f
C28 a_30_10# a_206_10# 6.73536f
C29 a_30_10# a_426_10# 2.36036f
C30 a_486_225# m1_402_252# 2.26836f
C31 a_30_10# a_294_150# 0.09642f
C32 a_30_10# a_190_5# 0.06059f
C33 a_30_10# a_74_10# 11.6463f
C34 a_30_10# a_146_145# 1.59305f
C35 a_30_10# a_410_5# 0.01403f
C36 a_30_10# a_266_10# 9.98991f
C37 a_266_150# m1_182_242# 0.58058f
C38 a_30_10# a_366_145# 0.04295f
C39 a_30_10# a_382_85# 6.98453f
C40 a_30_10# a_250_10# 2.2449f
C41 a_30_10# oh1 4.73453f
C42 a_30_10# a_338_150# 1.20886f
C43 a_30_10# a_234_5# 0.01784f
C44 a_30_10# a_162_10# 7.12798f
C45 a_30_10# m1_412_200# 0.0148f
C46 a_30_10# oh0 7.0533f
C47 a_30_10# a_190_145# 1.58529f
C48 a_30_10# a_294_85# 13.8939f
C49 a_294_225# m1_182_242# 6.96698f
C50 a_30_10# a_266_150# 8.50798f
C51 a_30_10# a_426_85# 2.32406f
C52 a_30_10# a_398_150# 4.72882f
C53 a_30_10# a_162_150# 3.65192f
C54 a_30_10# a_354_150# 4.44731f
C55 a_30_10# a_278_5# 0.01078f
C56 a_30_10# a_178_10# 21.5943f
C57 a_30_10# a_118_225# 8.56938f
C58 a_30_10# a_234_145# 3.17057f
C59 a_30_10# a_338_85# 2.28833f
C60 a_338_225# m1_182_242# 2.32233f
C61 VSS 0 0.66267p
C62 VDD 0 0.54692p
C63 m1_456_200# 0 5.24f $ **FLOATING
C64 m1_412_200# 0 5.24f
C65 m1_402_252# 0 16.791f
C66 m1_182_242# 0 25.8228f
C67 m1_16_200# 0 5.24f $ **FLOATING
C68 a_514_10# 0 91.25f $ **FLOATING
C69 a_470_10# 0 0.16506p $ **FLOATING
C70 a_426_10# 0 79.42f $ **FLOATING
C71 a_382_10# 0 0.16506p $ **FLOATING
C72 a_338_10# 0 79.42f $ **FLOATING
C73 a_294_10# 0 0.16506p $ **FLOATING
C74 a_250_10# 0 79.42f $ **FLOATING
C75 a_206_10# 0 0.16506p $ **FLOATING
C76 a_0_10# 0 91.25f $ **FLOATING
C77 a_498_5# 0 38.4776f $ **FLOATING
C78 a_454_5# 0 38.4387f $ **FLOATING
C79 a_410_5# 0 38.4387f $ **FLOATING
C80 a_366_5# 0 38.4387f $ **FLOATING
C81 a_322_5# 0 38.4387f $ **FLOATING
C82 a_278_5# 0 38.4387f $ **FLOATING
C83 a_234_5# 0 38.4387f $ **FLOATING
C84 a_190_5# 0 38.4387f $ **FLOATING
C85 bj 0 38.4387f $ **FLOATING
C86 aj 0 38.4387f $ **FLOATING
C87 bi 0 38.4387f $ **FLOATING
C88 ai 0 38.4776f $ **FLOATING
C89 a_514_85# 0 91.25f $ **FLOATING
C90 a_470_85# 0 0.16506p $ **FLOATING
C91 a_442_10# 0 0.17555p $ **FLOATING
C92 a_426_85# 0 79.42f $ **FLOATING
C93 a_382_85# 0 0.16506p $ **FLOATING
C94 a_354_10# 0 0.17558p $ **FLOATING
C95 a_338_85# 0 79.42f $ **FLOATING
C96 a_294_85# 0 0.16506p $ **FLOATING
C97 a_266_10# 0 0.17557p $ **FLOATING
C98 a_250_85# 0 79.42f $ **FLOATING
C99 a_206_85# 0 0.16506p $ **FLOATING
C100 a_178_10# 0 0.17543p $ **FLOATING
C101 a_162_10# 0 0.17538p $ **FLOATING
C102 a_74_10# 0 0.37255p $ **FLOATING
C103 a_0_85# 0 91.25f $ **FLOATING
C104 a_498_85# 0 6.59275f $ **FLOATING
C105 a_454_85# 0 6.5855f $ **FLOATING
C106 a_410_85# 0 6.5855f $ **FLOATING
C107 a_366_85# 0 6.5855f $ **FLOATING
C108 a_322_85# 0 6.5855f $ **FLOATING
C109 a_278_85# 0 6.5855f $ **FLOATING
C110 a_234_85# 0 6.5855f $ **FLOATING
C111 a_190_85# 0 6.5855f $ **FLOATING
C112 a_146_85# 0 6.5855f $ **FLOATING
C113 a_102_85# 0 6.5855f $ **FLOATING
C114 a_58_85# 0 6.5855f $ **FLOATING
C115 a_14_85# 0 6.59275f $ **FLOATING
C116 a_486_150# 0 79.42f $ **FLOATING
C117 a_470_150# 0 79.42f $ **FLOATING
C118 a_426_150# 0 0.16506p $ **FLOATING
C119 a_354_150# 0 76.48f $ **FLOATING
C120 a_338_150# 0 79.42f $ **FLOATING
C121 a_294_150# 0 0.16506p $ **FLOATING
C122 a_250_150# 0 79.42f $ **FLOATING
C123 a_206_150# 0 0.16506p $ **FLOATING
C124 a_162_150# 0 77.74f $ **FLOATING
C125 a_118_150# 0 0.16506p $ **FLOATING
C126 a_0_150# 0 91.25f $ **FLOATING
C127 a_498_145# 0 38.4776f $ **FLOATING
C128 a_454_145# 0 34.7233f $ **FLOATING
C129 a_410_145# 0 34.7233f $ **FLOATING
C130 a_366_145# 0 38.4387f $ **FLOATING
C131 a_322_145# 0 34.7233f $ **FLOATING
C132 a_278_145# 0 38.4387f $ **FLOATING
C133 a_234_145# 0 38.4387f $ **FLOATING
C134 a_190_145# 0 34.7233f $ **FLOATING
C135 a_146_145# 0 34.7233f $ **FLOATING
C136 a_102_145# 0 34.7233f $ **FLOATING
C137 a_58_145# 0 34.7233f $ **FLOATING
C138 a_14_145# 0 34.7622f $ **FLOATING
C139 oh2 0 0.20092p $ **FLOATING
C140 a_486_225# 0 79.42f $ **FLOATING
C141 a_470_225# 0 79.42f $ **FLOATING
C142 a_426_225# 0 0.16506p $ **FLOATING
C143 a_398_150# 0 0.17543p $ **FLOATING
C144 oh1 0 0.1771p $ **FLOATING
C145 a_354_225# 0 79.42f $ **FLOATING
C146 a_338_225# 0 79.42f $ **FLOATING
C147 a_294_225# 0 0.16506p $ **FLOATING
C148 a_266_150# 0 0.17553p $ **FLOATING
C149 a_250_225# 0 79.42f $ **FLOATING
C150 a_206_225# 0 0.16506p $ **FLOATING
C151 a_162_225# 0 79.42f $ **FLOATING
C152 a_118_225# 0 0.16506p $ **FLOATING
C153 oh0 0 0.17543p $ **FLOATING
C154 a_30_10# 0 1.90655p $ **FLOATING
C155 a_0_225# 0 91.25f $ **FLOATING
C156 a_498_225# 0 6.59275f $ **FLOATING
C157 a_454_225# 0 6.5855f $ **FLOATING
C158 a_410_225# 0 6.5855f $ **FLOATING
C159 a_366_225# 0 6.5855f $ **FLOATING
C160 a_322_225# 0 6.5855f $ **FLOATING
C161 a_278_225# 0 6.5855f $ **FLOATING
C162 a_234_225# 0 6.5855f $ **FLOATING
C163 a_190_225# 0 6.5855f $ **FLOATING
C164 a_146_225# 0 6.5855f $ **FLOATING
C165 a_102_225# 0 6.5855f $ **FLOATING
C166 a_58_225# 0 6.5855f $ **FLOATING
C167 a_14_225# 0 6.59275f $ **FLOATING
