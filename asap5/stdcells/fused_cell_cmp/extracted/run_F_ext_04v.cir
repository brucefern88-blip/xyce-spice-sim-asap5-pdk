* =============================================================================
* run_F_ext_04v.cir — FUSED_F Extracted Transient at SLVT 0.40V
* =============================================================================
* 42T hybrid fused Hamming cell with layout parasitic capacitances
* from Magic extraction (FUSED_F.ext, scale 1000 1 1, cap in aF /1000 = fF)
* Outputs: oh1 (hd=1), oh2 (hd=2) — 2-output variant (no oh0)
* ASAP5 SLVT, nfin=2, VDD=0.40V
* Run:  Xyce run_F_ext_04v.cir
* =============================================================================

.include '/Users/bruce/CLAUDE/asap5/spice/xyce_models/nmos_slvt_tt_cal.pm'
.include '/Users/bruce/CLAUDE/asap5/spice/xyce_models/pmos_slvt_tt_cal.pm'

.OPTIONS DEVICE GMIN=1e-12
.OPTIONS NONLIN RELTOL=1e-4 ABSTOL=1e-9
.OPTIONS TIMEINT METHOD=trap RELTOL=1e-3 ABSTOL=1e-12
.OPTIONS MEASURE MEASDGT=5

* --- Supply ---
Vvdd Vdd 0 0.40
Vgnd Gnd 0 0

* --- Stimulus: 4 input vectors sequentially ---
* 0-200ps:   ai=0 bi=0 aj=0 bj=0 -> hd=0 (oh1=0, oh2=0)
* 200-400ps: ai=1 bi=0 aj=0 bj=0 -> hd=1 (oh1=1, oh2=0)
* 400-600ps: ai=1 bi=0 aj=1 bj=0 -> hd=2 (oh1=0, oh2=1)
* 600-800ps: ai=0 bi=0 aj=1 bj=0 -> hd=1 (oh1=1, oh2=0)
Vin_ai ai 0 PWL(0 0 190p 0 200p 0.4 590p 0.4 600p 0 800p 0)
Vin_bi bi 0 DC 0
Vin_aj aj 0 PWL(0 0 390p 0 400p 0.4 800p 0.4)
Vin_bj bj 0 DC 0

* =============================================================================
* FUSED_F subcircuit — SLVT, nfin=2, with layout parasitics
* =============================================================================
* --- Input inverters (8T) ---
Mn_iai nai ai Gnd Gnd nmos_slvt l=16n nfin=2
Mp_iai nai ai Vdd Vdd pmos_slvt l=16n nfin=2
Mn_ibi nbi bi Gnd Gnd nmos_slvt l=16n nfin=2
Mp_ibi nbi bi Vdd Vdd pmos_slvt l=16n nfin=2
Mn_iaj naj aj Gnd Gnd nmos_slvt l=16n nfin=2
Mp_iaj naj aj Vdd Vdd pmos_slvt l=16n nfin=2
Mn_ibj nbj bj Gnd Gnd nmos_slvt l=16n nfin=2
Mp_ibj nbj bj Vdd Vdd pmos_slvt l=16n nfin=2

* --- XOR0 via OAI22: x0 = ai^bi (8T) ---
Mp_q0_1 x0 nai q0pm1 Vdd pmos_slvt l=16n nfin=2
Mp_q0_2 q0pm1 nbi Vdd Vdd pmos_slvt l=16n nfin=2
Mp_q0_3 x0 ai q0pm2 Vdd pmos_slvt l=16n nfin=2
Mp_q0_4 q0pm2 bi Vdd Vdd pmos_slvt l=16n nfin=2
Mn_q0_1 q0nmid nai Gnd Gnd nmos_slvt l=16n nfin=2
Mn_q0_2 q0nmid nbi Gnd Gnd nmos_slvt l=16n nfin=2
Mn_q0_3 x0 ai q0nmid Gnd nmos_slvt l=16n nfin=2
Mn_q0_4 x0 bi q0nmid Gnd nmos_slvt l=16n nfin=2

* --- XOR1 via OAI22: x1 = aj^bj (8T) ---
Mp_q1_1 x1 naj q1pm1 Vdd pmos_slvt l=16n nfin=2
Mp_q1_2 q1pm1 nbj Vdd Vdd pmos_slvt l=16n nfin=2
Mp_q1_3 x1 aj q1pm2 Vdd pmos_slvt l=16n nfin=2
Mp_q1_4 q1pm2 bj Vdd Vdd pmos_slvt l=16n nfin=2
Mn_q1_1 q1nmid naj Gnd Gnd nmos_slvt l=16n nfin=2
Mn_q1_2 q1nmid nbj Gnd Gnd nmos_slvt l=16n nfin=2
Mn_q1_3 x1 aj q1nmid Gnd nmos_slvt l=16n nfin=2
Mn_q1_4 x1 bj q1nmid Gnd nmos_slvt l=16n nfin=2

* --- XOR output inverters (4T) ---
Mn_ix0 d0 x0 Gnd Gnd nmos_slvt l=16n nfin=2
Mp_ix0 d0 x0 Vdd Vdd pmos_slvt l=16n nfin=2
Mn_ix1 d1 x1 Gnd Gnd nmos_slvt l=16n nfin=2
Mp_ix1 d1 x1 Vdd Vdd pmos_slvt l=16n nfin=2

* --- OH2: NOR2(x0,x1) (4T) ---
Mp_o2_1 o2ps x0 Vdd Vdd pmos_slvt l=16n nfin=2
Mp_o2_2 oh2 x1 o2ps Vdd pmos_slvt l=16n nfin=2
Mn_o2_1 oh2 x0 Gnd Gnd nmos_slvt l=16n nfin=2
Mn_o2_2 oh2 x1 Gnd Gnd nmos_slvt l=16n nfin=2

* --- OH1: AOI22(d0,x1, x0,d1) + INV (10T) ---
Mp_a1_1 a1pm d0 Vdd Vdd pmos_slvt l=16n nfin=2
Mp_a1_2 a1pm x1 Vdd Vdd pmos_slvt l=16n nfin=2
Mp_a1_3 no1 x0 a1pm Vdd pmos_slvt l=16n nfin=2
Mp_a1_4 no1 d1 a1pm Vdd pmos_slvt l=16n nfin=2
Mn_a1_1 no1 d0 a1nm1 Gnd nmos_slvt l=16n nfin=2
Mn_a1_2 a1nm1 x1 Gnd Gnd nmos_slvt l=16n nfin=2
Mn_a1_3 no1 x0 a1nm2 Gnd nmos_slvt l=16n nfin=2
Mn_a1_4 a1nm2 d1 Gnd Gnd nmos_slvt l=16n nfin=2
Mn_io1 oh1 no1 Gnd Gnd nmos_slvt l=16n nfin=2
Mp_io1 oh1 no1 Vdd Vdd pmos_slvt l=16n nfin=2

* =============================================================================
* Layout parasitic capacitances from FUSED_F.ext
* Source: Magic extraction, ASAP5 tech, scale 1000 1 1
* Conversion: raw aF / 1000 = fF
* =============================================================================
* --- Input pin parasitics ---
Cpar_ai   ai   0  0.130f
Cpar_bi   bi   0  0.130f
Cpar_aj   aj   0  0.135f
Cpar_bj   bj   0  0.135f
* --- Input inverter outputs ---
Cpar_nai  nai  0  0.20f
Cpar_nbi  nbi  0  0.20f
Cpar_naj  naj  0  0.20f
Cpar_nbj  nbj  0  0.20f
* --- OAI22 XOR outputs (x0, x1 drive NOR2+INV+AOI22 = 5 gate connections) ---
* x0 maps to heavily-routed node with M1/M2 vias; extracted nodes show
* significant coupling: a_250_85#=15.9fF, a_294_85#=14.5fF region
Cpar_x0   x0   0  6.0f
Cpar_x1   x1   0  6.0f
* --- XOR output inverter outputs (d0, d1 drive AOI22 = 2 gate connections) ---
* Extracted via M1_168_110# (38.9 fF) and M1_94_100# (41.5 fF) include
* routing caps to M2 layer — effective driven-node cap is smaller
Cpar_d0   d0   0  4.0f
Cpar_d1   d1   0  4.0f
* --- AOI22 internal node (no1) ---
* Maps to oh1 routing region: a_90_150#=8.8fF
Cpar_no1  no1  0  8.8f
* --- Output node parasitics from extraction ---
* oh1: substrate=1857 + coupling=2959 = 4816 aF = 4.82 fF
Cpar_oh1  oh1  0  4.82f
* oh2: substrate=3001 + coupling=53388 = 56389 aF = 56.4 fF
* NOTE: oh2 has very large coupling to M1/M2 via routing in extraction.
* The effective self-cap is much lower; use substrate + local coupling only.
* From node line: substrate=3001 aF = 3.0 fF; nearby coupling ~15 fF
Cpar_oh2  oh2  0  18.0f

* --- Output loads (external) ---
CL_oh1 oh1 0 1f
CL_oh2 oh2 0 1f

* =============================================================================
* Analysis
* =============================================================================
.TRAN 1p 800p

.PRINT TRAN V(ai) V(bi) V(aj) V(bj) V(oh1) V(oh2) I(Vvdd)

* --- OH1 transitions ---
.MEASURE TRAN tplh_oh1_1 TRIG V(ai) VAL=0.2 RISE=1 TARG V(oh1) VAL=0.2 RISE=1
.MEASURE TRAN tphl_oh1_1 TRIG V(aj) VAL=0.2 RISE=1 TARG V(oh1) VAL=0.2 FALL=1
.MEASURE TRAN tplh_oh1_2 TRIG V(ai) VAL=0.2 FALL=1 TARG V(oh1) VAL=0.2 RISE=2

* --- OH2 transitions ---
.MEASURE TRAN tplh_oh2_1 TRIG V(aj) VAL=0.2 RISE=1 TARG V(oh2) VAL=0.2 RISE=1
.MEASURE TRAN tphl_oh2_1 TRIG V(ai) VAL=0.2 FALL=1 TARG V(oh2) VAL=0.2 FALL=1

* --- Steady-state verification ---
.MEASURE TRAN v_oh1_hd0 FIND V(oh1) AT=180p
.MEASURE TRAN v_oh2_hd0 FIND V(oh2) AT=180p
.MEASURE TRAN v_oh1_hd1a FIND V(oh1) AT=380p
.MEASURE TRAN v_oh2_hd1a FIND V(oh2) AT=380p
.MEASURE TRAN v_oh1_hd2 FIND V(oh1) AT=580p
.MEASURE TRAN v_oh2_hd2 FIND V(oh2) AT=580p
.MEASURE TRAN v_oh1_hd1b FIND V(oh1) AT=780p
.MEASURE TRAN v_oh2_hd1b FIND V(oh2) AT=780p

.MEASURE TRAN i_avg AVG I(Vvdd) FROM=0 TO=800p

.END
