* NGSPICE file created from FUSED_F.ext - technology: asap5

.global Vdd Gnd

.subckt FUSED_F
M1000 a_294_85# a_278_5# a_250_85# w_0_65# pmos_slvt w=0.45u l=0.16u
+  ad=63f pd=0.73u as=63f ps=0.73u
M1001 a_162_225# a_146_145# a_118_225# Gnd nmos_slvt w=0.45u l=0.16u
+  ad=54f pd=1.14u as=63f ps=0.73u
M1002 a_30_225# a_14_145# oh2 Gnd nmos_slvt w=0.45u l=0.16u
+  ad=63f pd=0.73u as=63f ps=1.18u
M1003 a_338_85# a_322_5# a_294_85# w_0_65# pmos_slvt w=0.45u l=0.16u
+  ad=54f pd=1.14u as=63f ps=0.73u
M1004 a_74_10# bi VSS Gnd nmos_slvt w=0.45u l=0.16u
+  ad=63f pd=0.73u as=63f ps=0.73u
M1005 a_250_10# a_234_5# a_206_10# Gnd nmos_slvt w=0.45u l=0.16u
+  ad=63f pd=0.73u as=63f ps=0.73u
M1006 a_250_150# a_234_145# a_206_150# w_0_65# pmos_slvt w=0.45u l=0.16u
+  ad=63f pd=0.73u as=63f ps=0.73u
M1007 a_206_150# a_190_145# a_178_150# w_0_65# pmos_slvt w=0.45u l=0.16u
+  ad=63f pd=0.73u as=54f ps=1.14u
M1008 a_338_225# a_322_145# a_294_225# Gnd nmos_slvt w=0.45u l=0.16u
+  ad=54f pd=1.14u as=63f ps=0.73u
M1009 VDD aj a_74_10# w_0_65# pmos_slvt w=0.45u l=0.16u
+  ad=63f pd=0.73u as=63f ps=0.73u
M1010 a_74_150# a_58_145# VDD w_0_65# pmos_slvt w=0.45u l=0.16u
+  ad=63f pd=1.18u as=63f ps=0.73u
M1011 a_470_85# a_454_5# a_426_85# w_0_65# pmos_slvt w=0.45u l=0.16u
+  ad=63f pd=0.73u as=63f ps=0.73u
M1012 a_382_10# a_366_5# a_354_10# Gnd nmos_slvt w=0.45u l=0.16u
+  ad=63f pd=0.73u as=54f ps=1.14u
M1013 a_294_225# a_278_145# a_250_150# Gnd nmos_slvt w=0.45u l=0.16u
+  ad=63f pd=0.73u as=63f ps=0.73u
M1014 a_118_225# a_102_145# a_90_150# Gnd nmos_slvt w=0.45u l=0.16u
+  ad=63f pd=0.73u as=54f ps=1.14u
M1015 a_426_10# a_410_5# a_382_10# Gnd nmos_slvt w=0.45u l=0.16u
+  ad=63f pd=0.73u as=63f ps=0.73u
M1016 oh1 a_366_145# a_354_150# w_0_65# pmos_slvt w=0.45u l=0.16u
+  ad=63f pd=1.18u as=54f ps=1.14u
M1017 a_74_10# bi VDD w_0_65# pmos_slvt w=0.45u l=0.16u
+  ad=63f pd=0.73u as=63f ps=0.73u
M1018 a_250_85# a_234_5# a_206_85# w_0_65# pmos_slvt w=0.45u l=0.16u
+  ad=63f pd=0.73u as=63f ps=0.73u
M1019 a_162_10# bj VSS Gnd nmos_slvt w=0.45u l=0.16u
+  ad=63f pd=1.18u as=63f ps=0.73u
M1020 a_162_150# a_146_145# a_118_150# w_0_65# pmos_slvt w=0.45u l=0.16u
+  ad=54f pd=1.14u as=63f ps=0.73u
M1021 a_514_10# a_498_5# a_470_10# Gnd nmos_slvt w=0.45u l=0.16u
+  ad=63f pd=1.18u as=63f ps=0.73u
M1022 VSS ai a_0_10# Gnd nmos_slvt w=0.45u l=0.16u
+  ad=63f pd=0.73u as=63f ps=1.18u
M1023 a_206_10# a_190_5# a_178_10# Gnd nmos_slvt w=0.45u l=0.16u
+  ad=63f pd=0.73u as=54f ps=1.14u
M1024 VDD a_14_145# oh2 w_0_65# pmos_slvt w=0.45u l=0.16u
+  ad=63f pd=0.73u as=63f ps=1.18u
M1025 a_250_150# a_234_145# a_206_225# Gnd nmos_slvt w=0.45u l=0.16u
+  ad=63f pd=0.73u as=63f ps=0.73u
M1026 a_206_225# a_190_145# a_178_150# Gnd nmos_slvt w=0.45u l=0.16u
+  ad=63f pd=0.73u as=54f ps=1.14u
M1027 a_382_85# a_366_5# a_354_85# w_0_65# pmos_slvt w=0.45u l=0.16u
+  ad=63f pd=0.73u as=54f ps=1.14u
M1028 a_294_10# a_278_5# a_250_10# Gnd nmos_slvt w=0.45u l=0.16u
+  ad=63f pd=0.73u as=63f ps=0.73u
M1029 a_338_150# a_322_145# a_294_150# w_0_65# pmos_slvt w=0.45u l=0.16u
+  ad=54f pd=1.14u as=63f ps=0.73u
M1030 a_426_85# a_410_5# a_382_85# w_0_65# pmos_slvt w=0.45u l=0.16u
+  ad=63f pd=0.73u as=63f ps=0.73u
M1031 a_338_10# a_322_5# a_294_10# Gnd nmos_slvt w=0.45u l=0.16u
+  ad=54f pd=1.14u as=63f ps=0.73u
M1032 a_74_150# a_58_145# a_30_225# Gnd nmos_slvt w=0.45u l=0.16u
+  ad=63f pd=1.18u as=63f ps=0.73u
M1033 a_118_150# a_102_145# a_90_150# w_0_65# pmos_slvt w=0.45u l=0.16u
+  ad=63f pd=0.73u as=54f ps=1.14u
M1034 a_294_150# a_278_145# a_250_150# w_0_65# pmos_slvt w=0.45u l=0.16u
+  ad=63f pd=0.73u as=63f ps=0.73u
M1035 a_162_10# bj VDD w_0_65# pmos_slvt w=0.45u l=0.16u
+  ad=63f pd=1.18u as=63f ps=0.73u
M1036 a_514_85# a_498_5# a_470_85# w_0_65# pmos_slvt w=0.45u l=0.16u
+  ad=63f pd=1.18u as=63f ps=0.73u
M1037 VDD ai a_0_10# w_0_65# pmos_slvt w=0.45u l=0.16u
+  ad=63f pd=0.73u as=63f ps=1.18u
M1038 VSS aj a_74_10# Gnd nmos_slvt w=0.45u l=0.16u
+  ad=63f pd=0.73u as=63f ps=0.73u
M1039 oh1 a_366_145# a_354_225# Gnd nmos_slvt w=0.45u l=0.16u
+  ad=63f pd=1.18u as=54f ps=1.14u
M1040 a_206_85# a_190_5# a_178_85# w_0_65# pmos_slvt w=0.45u l=0.16u
+  ad=63f pd=0.73u as=54f ps=1.14u
M1041 a_470_10# a_454_5# a_426_10# Gnd nmos_slvt w=0.45u l=0.16u
+  ad=63f pd=0.73u as=63f ps=0.73u
.ends
