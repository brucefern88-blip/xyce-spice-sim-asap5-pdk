* FUSED_E (38T) — 16-vector transient, Xyce BSIM-CMG
* Post-layout parasitics from Magic ASAP5 extraction
.include '/Users/bruce/CLAUDE/asap5/spice/xyce_models/nmos_slvt_tt_cal.pm'
.include '/Users/bruce/CLAUDE/asap5/spice/xyce_models/pmos_slvt_tt_cal.pm'
.OPTIONS DEVICE GMIN=1e-12
.OPTIONS NONLIN RELTOL=1e-4 ABSTOL=1e-9
.OPTIONS TIMEINT METHOD=trap RELTOL=1e-3 ABSTOL=1e-12
.OPTIONS MEASURE MEASDGT=6

Vvdd VDD 0 0.4

* 16 vectors x 1ns = 16ns, 5ps rise/fall
Vai ai 0 PWL(0.0000e+00 0.0 1.0000e-09 0.0 2.0000e-09 0.0 3.0000e-09 0.0 4.0000e-09 0.0 5.0000e-09 0.0 6.0000e-09 0.0 7.0000e-09 0.0 8.0000e-09 0.0 8.0050e-09 0.5 9.0000e-09 0.5 1.0000e-08 0.5 1.1000e-08 0.5 1.2000e-08 0.5 1.3000e-08 0.5 1.4000e-08 0.5 1.5000e-08 0.4)
Vbi bi 0 PWL(0.0000e+00 0.0 1.0000e-09 0.0 2.0000e-09 0.0 3.0000e-09 0.0 4.0000e-09 0.0 4.0050e-09 0.5 5.0000e-09 0.5 6.0000e-09 0.5 7.0000e-09 0.5 8.0000e-09 0.5 8.0050e-09 0.0 9.0000e-09 0.0 1.0000e-08 0.0 1.1000e-08 0.0 1.2000e-08 0.0 1.2005e-08 0.5 1.3000e-08 0.5 1.4000e-08 0.5 1.5000e-08 0.4)
Vaj aj 0 PWL(0.0000e+00 0.0 1.0000e-09 0.0 2.0000e-09 0.0 2.0050e-09 0.5 3.0000e-09 0.5 4.0000e-09 0.5 4.0050e-09 0.0 5.0000e-09 0.0 6.0000e-09 0.0 6.0050e-09 0.5 7.0000e-09 0.5 8.0000e-09 0.5 8.0050e-09 0.0 9.0000e-09 0.0 1.0000e-08 0.0 1.0005e-08 0.5 1.1000e-08 0.5 1.2000e-08 0.5 1.2005e-08 0.0 1.3000e-08 0.0 1.4000e-08 0.0 1.4005e-08 0.5 1.5000e-08 0.4)
Vbj bj 0 PWL(0.0000e+00 0.0 1.0000e-09 0.0 1.0050e-09 0.5 2.0000e-09 0.5 2.0050e-09 0.0 3.0000e-09 0.0 3.0050e-09 0.5 4.0000e-09 0.5 4.0050e-09 0.0 5.0000e-09 0.0 5.0050e-09 0.5 6.0000e-09 0.5 6.0050e-09 0.0 7.0000e-09 0.0 7.0050e-09 0.5 8.0000e-09 0.5 8.0050e-09 0.0 9.0000e-09 0.0 9.0050e-09 0.5 1.0000e-08 0.5 1.0005e-08 0.0 1.1000e-08 0.0 1.1005e-08 0.5 1.2000e-08 0.5 1.2005e-08 0.0 1.3000e-08 0.0 1.3005e-08 0.5 1.4000e-08 0.5 1.4005e-08 0.0 1.5000e-08 0.0 1.5005e-08 0.4)

* === E circuit (38T) ===
Mp_ia nai ai VDD VDD pmos_slvt l=16n nfin=2
Mn_ia nai ai 0 0 nmos_slvt l=16n nfin=2
Mp_ib nbi bi VDD VDD pmos_slvt l=16n nfin=2
Mn_ib nbi bi 0 0 nmos_slvt l=16n nfin=2
Mp_iaj naj aj VDD VDD pmos_slvt l=16n nfin=2
Mn_iaj naj aj 0 0 nmos_slvt l=16n nfin=2
Mp_ibj nbj bj VDD VDD pmos_slvt l=16n nfin=2
Mn_ibj nbj bj 0 0 nmos_slvt l=16n nfin=2
Mp1_q0 x0 nai q0_pm1 VDD pmos_slvt l=16n nfin=2
Mp2_q0 q0_pm1 nbi VDD VDD pmos_slvt l=16n nfin=2
Mp3_q0 x0 ai q0_pm2 VDD pmos_slvt l=16n nfin=2
Mp4_q0 q0_pm2 bi VDD VDD pmos_slvt l=16n nfin=2
Mn1_q0 q0_nmid nai 0 0 nmos_slvt l=16n nfin=2
Mn2_q0 q0_nmid nbi 0 0 nmos_slvt l=16n nfin=2
Mn3_q0 x0 ai q0_nmid 0 nmos_slvt l=16n nfin=2
Mn4_q0 x0 bi q0_nmid 0 nmos_slvt l=16n nfin=2
Mp1_q1 x1 naj q1_pm1 VDD pmos_slvt l=16n nfin=2
Mp2_q1 q1_pm1 nbj VDD VDD pmos_slvt l=16n nfin=2
Mp3_q1 x1 aj q1_pm2 VDD pmos_slvt l=16n nfin=2
Mp4_q1 q1_pm2 bj VDD VDD pmos_slvt l=16n nfin=2
Mn1_q1 q1_nmid naj 0 0 nmos_slvt l=16n nfin=2
Mn2_q1 q1_nmid nbj 0 0 nmos_slvt l=16n nfin=2
Mn3_q1 x1 aj q1_nmid 0 nmos_slvt l=16n nfin=2
Mn4_q1 x1 bj q1_nmid 0 nmos_slvt l=16n nfin=2
Mp1_o2 o2_ps x0 VDD VDD pmos_slvt l=16n nfin=2
Mp2_o2 oh2 x1 o2_ps VDD pmos_slvt l=16n nfin=2
Mn1_o2 oh2 x0 0 0 nmos_slvt l=16n nfin=2
Mn2_o2 oh2 x1 0 0 nmos_slvt l=16n nfin=2
Mp1_n0 no0 x0 VDD VDD pmos_slvt l=16n nfin=2
Mp2_n0 no0 x1 VDD VDD pmos_slvt l=16n nfin=2
Mn1_n0 no0 x0 n0_ns 0 nmos_slvt l=16n nfin=2
Mn2_n0 n0_ns x1 0 0 nmos_slvt l=16n nfin=2
Mp_io0 oh0 no0 VDD VDD pmos_slvt l=16n nfin=2
Mn_io0 oh0 no0 0 0 nmos_slvt l=16n nfin=2
Mp1_o1 o1_ps oh0 VDD VDD pmos_slvt l=16n nfin=2
Mp2_o1 oh1 oh2 o1_ps VDD pmos_slvt l=16n nfin=2
Mn1_o1 oh1 oh0 0 0 nmos_slvt l=16n nfin=2
Mn2_o1 oh1 oh2 0 0 nmos_slvt l=16n nfin=2

CL_oh0 oh0 0 1f
CL_oh1 oh1 0 1f
CL_oh2 oh2 0 1f

* Estimated wire parasitics (from layout geometry)
Cwire_0 nai 0 0.3f
Cwire_1 nbi 0 0.3f
Cwire_2 naj 0 0.3f
Cwire_3 nbj 0 0.3f
Cwire_4 x0 0 0.3f
Cwire_5 x1 0 0.3f
Cwire_6 no0 0 0.3f

.TRAN 1p 1.6000e-08

.PRINT TRAN V(ai) V(bi) V(aj) V(bj) V(oh0) V(oh1) V(oh2) I(Vvdd)

* Functional verification: sample at 0.8ns into each vector
.MEASURE TRAN v_oh0_v0 FIND V(oh0) AT=8.0000e-10
.MEASURE TRAN v_oh1_v0 FIND V(oh1) AT=8.0000e-10
.MEASURE TRAN v_oh2_v0 FIND V(oh2) AT=8.0000e-10
.MEASURE TRAN v_oh0_v1 FIND V(oh0) AT=1.8000e-09
.MEASURE TRAN v_oh1_v1 FIND V(oh1) AT=1.8000e-09
.MEASURE TRAN v_oh2_v1 FIND V(oh2) AT=1.8000e-09
.MEASURE TRAN v_oh0_v2 FIND V(oh0) AT=2.8000e-09
.MEASURE TRAN v_oh1_v2 FIND V(oh1) AT=2.8000e-09
.MEASURE TRAN v_oh2_v2 FIND V(oh2) AT=2.8000e-09
.MEASURE TRAN v_oh0_v3 FIND V(oh0) AT=3.8000e-09
.MEASURE TRAN v_oh1_v3 FIND V(oh1) AT=3.8000e-09
.MEASURE TRAN v_oh2_v3 FIND V(oh2) AT=3.8000e-09
.MEASURE TRAN v_oh0_v4 FIND V(oh0) AT=4.8000e-09
.MEASURE TRAN v_oh1_v4 FIND V(oh1) AT=4.8000e-09
.MEASURE TRAN v_oh2_v4 FIND V(oh2) AT=4.8000e-09
.MEASURE TRAN v_oh0_v5 FIND V(oh0) AT=5.8000e-09
.MEASURE TRAN v_oh1_v5 FIND V(oh1) AT=5.8000e-09
.MEASURE TRAN v_oh2_v5 FIND V(oh2) AT=5.8000e-09
.MEASURE TRAN v_oh0_v6 FIND V(oh0) AT=6.8000e-09
.MEASURE TRAN v_oh1_v6 FIND V(oh1) AT=6.8000e-09
.MEASURE TRAN v_oh2_v6 FIND V(oh2) AT=6.8000e-09
.MEASURE TRAN v_oh0_v7 FIND V(oh0) AT=7.8000e-09
.MEASURE TRAN v_oh1_v7 FIND V(oh1) AT=7.8000e-09
.MEASURE TRAN v_oh2_v7 FIND V(oh2) AT=7.8000e-09
.MEASURE TRAN v_oh0_v8 FIND V(oh0) AT=8.8000e-09
.MEASURE TRAN v_oh1_v8 FIND V(oh1) AT=8.8000e-09
.MEASURE TRAN v_oh2_v8 FIND V(oh2) AT=8.8000e-09
.MEASURE TRAN v_oh0_v9 FIND V(oh0) AT=9.8000e-09
.MEASURE TRAN v_oh1_v9 FIND V(oh1) AT=9.8000e-09
.MEASURE TRAN v_oh2_v9 FIND V(oh2) AT=9.8000e-09
.MEASURE TRAN v_oh0_v10 FIND V(oh0) AT=1.0800e-08
.MEASURE TRAN v_oh1_v10 FIND V(oh1) AT=1.0800e-08
.MEASURE TRAN v_oh2_v10 FIND V(oh2) AT=1.0800e-08
.MEASURE TRAN v_oh0_v11 FIND V(oh0) AT=1.1800e-08
.MEASURE TRAN v_oh1_v11 FIND V(oh1) AT=1.1800e-08
.MEASURE TRAN v_oh2_v11 FIND V(oh2) AT=1.1800e-08
.MEASURE TRAN v_oh0_v12 FIND V(oh0) AT=1.2800e-08
.MEASURE TRAN v_oh1_v12 FIND V(oh1) AT=1.2800e-08
.MEASURE TRAN v_oh2_v12 FIND V(oh2) AT=1.2800e-08
.MEASURE TRAN v_oh0_v13 FIND V(oh0) AT=1.3800e-08
.MEASURE TRAN v_oh1_v13 FIND V(oh1) AT=1.3800e-08
.MEASURE TRAN v_oh2_v13 FIND V(oh2) AT=1.3800e-08
.MEASURE TRAN v_oh0_v14 FIND V(oh0) AT=1.4800e-08
.MEASURE TRAN v_oh1_v14 FIND V(oh1) AT=1.4800e-08
.MEASURE TRAN v_oh2_v14 FIND V(oh2) AT=1.4800e-08
.MEASURE TRAN v_oh0_v15 FIND V(oh0) AT=1.5800e-08
.MEASURE TRAN v_oh1_v15 FIND V(oh1) AT=1.5800e-08
.MEASURE TRAN v_oh2_v15 FIND V(oh2) AT=1.5800e-08

* Delay: bi rises at vec4 (4ns), oh1 should rise
.MEASURE TRAN t_bi_rise WHEN V(bi)=0.25 RISE=1
.MEASURE TRAN t_oh1_rise WHEN V(oh1)=0.25 RISE=1
.MEASURE TRAN tpd_oh1 PARAM='t_oh1_rise - t_bi_rise'
.MEASURE TRAN i_avg AVG I(Vvdd) FROM=0 TO=1.6000e-08
.MEASURE TRAN i_switch AVG I(Vvdd) FROM=4.0000e-09 TO=8.0000e-09

.END
