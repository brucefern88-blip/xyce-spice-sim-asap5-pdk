* NGSPICE file created from AOI21x1.ext - technology: asap5

.global Vdd 0

* Top level circuit AOI21x1

.end
