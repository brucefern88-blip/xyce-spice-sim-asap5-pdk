* NGSPICE file created from XNOR2x2.ext - technology: asap5

.global Vdd 0

* Top level circuit XNOR2x2

.end
