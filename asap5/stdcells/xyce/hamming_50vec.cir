* Hamming 64b Cuboid R4 — Xyce Power Simulation
* ASAP5 5nm GAA Nanosheet, BSIM-CMG level=107
* 1564 transistors, RC-extracted, 1000 random vectors

.include '/Users/bruce/CLAUDE/asap5/spice/xyce_models/nmos_lvt_tt.pm'
.include '/Users/bruce/CLAUDE/asap5/spice/xyce_models/pmos_lvt_tt.pm'

Vvdd VDD 0 0.5
Vvss VSS 0 0

* Full RC-Extracted Flat SPICE
* Device: ASAP5 5nm GAA nanosheet (Magic-extracted W/L + AD/AS/PD/PS)
* Wire RC: from OpenROAD routed DEF (M1-M4)
* Via R: 10 ohm/via
* Cells: 32 FUSED_G + 64 INVx1 + 32 NOR2x1 + 7 BUFx1

* MOSFET models (level=1, calibrated to ASAP5 LVT at VDD=0.5V)
* ASAP5 is BSIM-CMG level=72 geomod=3, but ngspice needs level=1
* Vt calibrated from ASAP5 Id-Vgs: NMOS Vt~0.15V, PMOS Vt~-0.15V

* FUSED_G fg00 (40T, ASAP5 extracted: W=0.45u L=0.16u)
MN_ifg00_nai ifg00_nai A[0] VSS VSS nmos_lvt l=16n nfin=2
MP_ifg00_nai ifg00_nai A[0] VDD VDD pmos_lvt l=16n nfin=2
MN_ifg00_nbi ifg00_nbi B[0] VSS VSS nmos_lvt l=16n nfin=2
MP_ifg00_nbi ifg00_nbi B[0] VDD VDD pmos_lvt l=16n nfin=2
MN_ifg00_naj ifg00_naj A[1] VSS VSS nmos_lvt l=16n nfin=2
MP_ifg00_naj ifg00_naj A[1] VDD VDD pmos_lvt l=16n nfin=2
MN_ifg00_nbj ifg00_nbj B[1] VSS VSS nmos_lvt l=16n nfin=2
MP_ifg00_nbj ifg00_nbj B[1] VDD VDD pmos_lvt l=16n nfin=2
MP_q01_fg00 ifg00_x0 ifg00_nai ifg00_q0p1 VDD pmos_lvt l=16n nfin=2
MP_q02_fg00 ifg00_q0p1 ifg00_nbi VDD VDD pmos_lvt l=16n nfin=2
MP_q03_fg00 ifg00_x0 A[0] ifg00_q0p2 VDD pmos_lvt l=16n nfin=2
MP_q04_fg00 ifg00_q0p2 B[0] VDD VDD pmos_lvt l=16n nfin=2
MN_q01_fg00 ifg00_q0n ifg00_nai VSS VSS nmos_lvt l=16n nfin=2
MN_q02_fg00 ifg00_q0n ifg00_nbi VSS VSS nmos_lvt l=16n nfin=2
MN_q03_fg00 ifg00_x0 A[0] ifg00_q0n VSS nmos_lvt l=16n nfin=2
MN_q04_fg00 ifg00_x0 B[0] ifg00_q0n VSS nmos_lvt l=16n nfin=2
MP_q11_fg00 ifg00_x1 ifg00_naj ifg00_q1p1 VDD pmos_lvt l=16n nfin=2
MP_q12_fg00 ifg00_q1p1 ifg00_nbj VDD VDD pmos_lvt l=16n nfin=2
MP_q13_fg00 ifg00_x1 A[1] ifg00_q1p2 VDD pmos_lvt l=16n nfin=2
MP_q14_fg00 ifg00_q1p2 B[1] VDD VDD pmos_lvt l=16n nfin=2
MN_q11_fg00 ifg00_q1n ifg00_naj VSS VSS nmos_lvt l=16n nfin=2
MN_q12_fg00 ifg00_q1n ifg00_nbj VSS VSS nmos_lvt l=16n nfin=2
MN_q13_fg00 ifg00_x1 A[1] ifg00_q1n VSS nmos_lvt l=16n nfin=2
MN_q14_fg00 ifg00_x1 B[1] ifg00_q1n VSS nmos_lvt l=16n nfin=2
MN_ix0_fg00 ifg00_d0 ifg00_x0 VSS VSS nmos_lvt l=16n nfin=2
MP_ix0_fg00 ifg00_d0 ifg00_x0 VDD VDD pmos_lvt l=16n nfin=2
MN_ix1_fg00 ifg00_d1 ifg00_x1 VSS VSS nmos_lvt l=16n nfin=2
MP_ix1_fg00 ifg00_d1 ifg00_x1 VDD VDD pmos_lvt l=16n nfin=2
MP_a11_fg00 ifg00_a1p ifg00_d0 VDD VDD pmos_lvt l=16n nfin=2
MP_a12_fg00 ifg00_a1p ifg00_x1 VDD VDD pmos_lvt l=16n nfin=2
MP_a13_fg00 noh1[0] ifg00_x0 ifg00_a1p VDD pmos_lvt l=16n nfin=2
MP_a14_fg00 noh1[0] ifg00_d1 ifg00_a1p VDD pmos_lvt l=16n nfin=2
MN_a11_fg00 noh1[0] ifg00_d0 ifg00_a1n1 VSS nmos_lvt l=16n nfin=2
MN_a12_fg00 ifg00_a1n1 ifg00_x1 VSS VSS nmos_lvt l=16n nfin=2
MN_a13_fg00 noh1[0] ifg00_x0 ifg00_a1n2 VSS nmos_lvt l=16n nfin=2
MN_a14_fg00 ifg00_a1n2 ifg00_d1 VSS VSS nmos_lvt l=16n nfin=2
MP_n21_fg00 noh2[0] ifg00_d0 VDD VDD pmos_lvt l=16n nfin=2
MP_n22_fg00 noh2[0] ifg00_d1 VDD VDD pmos_lvt l=16n nfin=2
MN_n21_fg00 noh2[0] ifg00_d0 ifg00_n2s VSS nmos_lvt l=16n nfin=2
MN_n22_fg00 ifg00_n2s ifg00_d1 VSS VSS nmos_lvt l=16n nfin=2

* FUSED_G fg01 (40T, ASAP5 extracted: W=0.45u L=0.16u)
MN_ifg01_nai ifg01_nai A[2] VSS VSS nmos_lvt l=16n nfin=2
MP_ifg01_nai ifg01_nai A[2] VDD VDD pmos_lvt l=16n nfin=2
MN_ifg01_nbi ifg01_nbi B[2] VSS VSS nmos_lvt l=16n nfin=2
MP_ifg01_nbi ifg01_nbi B[2] VDD VDD pmos_lvt l=16n nfin=2
MN_ifg01_naj ifg01_naj A[3] VSS VSS nmos_lvt l=16n nfin=2
MP_ifg01_naj ifg01_naj A[3] VDD VDD pmos_lvt l=16n nfin=2
MN_ifg01_nbj ifg01_nbj B[3] VSS VSS nmos_lvt l=16n nfin=2
MP_ifg01_nbj ifg01_nbj B[3] VDD VDD pmos_lvt l=16n nfin=2
MP_q01_fg01 ifg01_x0 ifg01_nai ifg01_q0p1 VDD pmos_lvt l=16n nfin=2
MP_q02_fg01 ifg01_q0p1 ifg01_nbi VDD VDD pmos_lvt l=16n nfin=2
MP_q03_fg01 ifg01_x0 A[2] ifg01_q0p2 VDD pmos_lvt l=16n nfin=2
MP_q04_fg01 ifg01_q0p2 B[2] VDD VDD pmos_lvt l=16n nfin=2
MN_q01_fg01 ifg01_q0n ifg01_nai VSS VSS nmos_lvt l=16n nfin=2
MN_q02_fg01 ifg01_q0n ifg01_nbi VSS VSS nmos_lvt l=16n nfin=2
MN_q03_fg01 ifg01_x0 A[2] ifg01_q0n VSS nmos_lvt l=16n nfin=2
MN_q04_fg01 ifg01_x0 B[2] ifg01_q0n VSS nmos_lvt l=16n nfin=2
MP_q11_fg01 ifg01_x1 ifg01_naj ifg01_q1p1 VDD pmos_lvt l=16n nfin=2
MP_q12_fg01 ifg01_q1p1 ifg01_nbj VDD VDD pmos_lvt l=16n nfin=2
MP_q13_fg01 ifg01_x1 A[3] ifg01_q1p2 VDD pmos_lvt l=16n nfin=2
MP_q14_fg01 ifg01_q1p2 B[3] VDD VDD pmos_lvt l=16n nfin=2
MN_q11_fg01 ifg01_q1n ifg01_naj VSS VSS nmos_lvt l=16n nfin=2
MN_q12_fg01 ifg01_q1n ifg01_nbj VSS VSS nmos_lvt l=16n nfin=2
MN_q13_fg01 ifg01_x1 A[3] ifg01_q1n VSS nmos_lvt l=16n nfin=2
MN_q14_fg01 ifg01_x1 B[3] ifg01_q1n VSS nmos_lvt l=16n nfin=2
MN_ix0_fg01 ifg01_d0 ifg01_x0 VSS VSS nmos_lvt l=16n nfin=2
MP_ix0_fg01 ifg01_d0 ifg01_x0 VDD VDD pmos_lvt l=16n nfin=2
MN_ix1_fg01 ifg01_d1 ifg01_x1 VSS VSS nmos_lvt l=16n nfin=2
MP_ix1_fg01 ifg01_d1 ifg01_x1 VDD VDD pmos_lvt l=16n nfin=2
MP_a11_fg01 ifg01_a1p ifg01_d0 VDD VDD pmos_lvt l=16n nfin=2
MP_a12_fg01 ifg01_a1p ifg01_x1 VDD VDD pmos_lvt l=16n nfin=2
MP_a13_fg01 noh1[1] ifg01_x0 ifg01_a1p VDD pmos_lvt l=16n nfin=2
MP_a14_fg01 noh1[1] ifg01_d1 ifg01_a1p VDD pmos_lvt l=16n nfin=2
MN_a11_fg01 noh1[1] ifg01_d0 ifg01_a1n1 VSS nmos_lvt l=16n nfin=2
MN_a12_fg01 ifg01_a1n1 ifg01_x1 VSS VSS nmos_lvt l=16n nfin=2
MN_a13_fg01 noh1[1] ifg01_x0 ifg01_a1n2 VSS nmos_lvt l=16n nfin=2
MN_a14_fg01 ifg01_a1n2 ifg01_d1 VSS VSS nmos_lvt l=16n nfin=2
MP_n21_fg01 noh2[1] ifg01_d0 VDD VDD pmos_lvt l=16n nfin=2
MP_n22_fg01 noh2[1] ifg01_d1 VDD VDD pmos_lvt l=16n nfin=2
MN_n21_fg01 noh2[1] ifg01_d0 ifg01_n2s VSS nmos_lvt l=16n nfin=2
MN_n22_fg01 ifg01_n2s ifg01_d1 VSS VSS nmos_lvt l=16n nfin=2

* FUSED_G fg02 (40T, ASAP5 extracted: W=0.45u L=0.16u)
MN_ifg02_nai ifg02_nai A[4] VSS VSS nmos_lvt l=16n nfin=2
MP_ifg02_nai ifg02_nai A[4] VDD VDD pmos_lvt l=16n nfin=2
MN_ifg02_nbi ifg02_nbi B[4] VSS VSS nmos_lvt l=16n nfin=2
MP_ifg02_nbi ifg02_nbi B[4] VDD VDD pmos_lvt l=16n nfin=2
MN_ifg02_naj ifg02_naj A[5] VSS VSS nmos_lvt l=16n nfin=2
MP_ifg02_naj ifg02_naj A[5] VDD VDD pmos_lvt l=16n nfin=2
MN_ifg02_nbj ifg02_nbj B[5] VSS VSS nmos_lvt l=16n nfin=2
MP_ifg02_nbj ifg02_nbj B[5] VDD VDD pmos_lvt l=16n nfin=2
MP_q01_fg02 ifg02_x0 ifg02_nai ifg02_q0p1 VDD pmos_lvt l=16n nfin=2
MP_q02_fg02 ifg02_q0p1 ifg02_nbi VDD VDD pmos_lvt l=16n nfin=2
MP_q03_fg02 ifg02_x0 A[4] ifg02_q0p2 VDD pmos_lvt l=16n nfin=2
MP_q04_fg02 ifg02_q0p2 B[4] VDD VDD pmos_lvt l=16n nfin=2
MN_q01_fg02 ifg02_q0n ifg02_nai VSS VSS nmos_lvt l=16n nfin=2
MN_q02_fg02 ifg02_q0n ifg02_nbi VSS VSS nmos_lvt l=16n nfin=2
MN_q03_fg02 ifg02_x0 A[4] ifg02_q0n VSS nmos_lvt l=16n nfin=2
MN_q04_fg02 ifg02_x0 B[4] ifg02_q0n VSS nmos_lvt l=16n nfin=2
MP_q11_fg02 ifg02_x1 ifg02_naj ifg02_q1p1 VDD pmos_lvt l=16n nfin=2
MP_q12_fg02 ifg02_q1p1 ifg02_nbj VDD VDD pmos_lvt l=16n nfin=2
MP_q13_fg02 ifg02_x1 A[5] ifg02_q1p2 VDD pmos_lvt l=16n nfin=2
MP_q14_fg02 ifg02_q1p2 B[5] VDD VDD pmos_lvt l=16n nfin=2
MN_q11_fg02 ifg02_q1n ifg02_naj VSS VSS nmos_lvt l=16n nfin=2
MN_q12_fg02 ifg02_q1n ifg02_nbj VSS VSS nmos_lvt l=16n nfin=2
MN_q13_fg02 ifg02_x1 A[5] ifg02_q1n VSS nmos_lvt l=16n nfin=2
MN_q14_fg02 ifg02_x1 B[5] ifg02_q1n VSS nmos_lvt l=16n nfin=2
MN_ix0_fg02 ifg02_d0 ifg02_x0 VSS VSS nmos_lvt l=16n nfin=2
MP_ix0_fg02 ifg02_d0 ifg02_x0 VDD VDD pmos_lvt l=16n nfin=2
MN_ix1_fg02 ifg02_d1 ifg02_x1 VSS VSS nmos_lvt l=16n nfin=2
MP_ix1_fg02 ifg02_d1 ifg02_x1 VDD VDD pmos_lvt l=16n nfin=2
MP_a11_fg02 ifg02_a1p ifg02_d0 VDD VDD pmos_lvt l=16n nfin=2
MP_a12_fg02 ifg02_a1p ifg02_x1 VDD VDD pmos_lvt l=16n nfin=2
MP_a13_fg02 noh1[2] ifg02_x0 ifg02_a1p VDD pmos_lvt l=16n nfin=2
MP_a14_fg02 noh1[2] ifg02_d1 ifg02_a1p VDD pmos_lvt l=16n nfin=2
MN_a11_fg02 noh1[2] ifg02_d0 ifg02_a1n1 VSS nmos_lvt l=16n nfin=2
MN_a12_fg02 ifg02_a1n1 ifg02_x1 VSS VSS nmos_lvt l=16n nfin=2
MN_a13_fg02 noh1[2] ifg02_x0 ifg02_a1n2 VSS nmos_lvt l=16n nfin=2
MN_a14_fg02 ifg02_a1n2 ifg02_d1 VSS VSS nmos_lvt l=16n nfin=2
MP_n21_fg02 noh2[2] ifg02_d0 VDD VDD pmos_lvt l=16n nfin=2
MP_n22_fg02 noh2[2] ifg02_d1 VDD VDD pmos_lvt l=16n nfin=2
MN_n21_fg02 noh2[2] ifg02_d0 ifg02_n2s VSS nmos_lvt l=16n nfin=2
MN_n22_fg02 ifg02_n2s ifg02_d1 VSS VSS nmos_lvt l=16n nfin=2

* FUSED_G fg03 (40T, ASAP5 extracted: W=0.45u L=0.16u)
MN_ifg03_nai ifg03_nai A[6] VSS VSS nmos_lvt l=16n nfin=2
MP_ifg03_nai ifg03_nai A[6] VDD VDD pmos_lvt l=16n nfin=2
MN_ifg03_nbi ifg03_nbi B[6] VSS VSS nmos_lvt l=16n nfin=2
MP_ifg03_nbi ifg03_nbi B[6] VDD VDD pmos_lvt l=16n nfin=2
MN_ifg03_naj ifg03_naj A[7] VSS VSS nmos_lvt l=16n nfin=2
MP_ifg03_naj ifg03_naj A[7] VDD VDD pmos_lvt l=16n nfin=2
MN_ifg03_nbj ifg03_nbj B[7] VSS VSS nmos_lvt l=16n nfin=2
MP_ifg03_nbj ifg03_nbj B[7] VDD VDD pmos_lvt l=16n nfin=2
MP_q01_fg03 ifg03_x0 ifg03_nai ifg03_q0p1 VDD pmos_lvt l=16n nfin=2
MP_q02_fg03 ifg03_q0p1 ifg03_nbi VDD VDD pmos_lvt l=16n nfin=2
MP_q03_fg03 ifg03_x0 A[6] ifg03_q0p2 VDD pmos_lvt l=16n nfin=2
MP_q04_fg03 ifg03_q0p2 B[6] VDD VDD pmos_lvt l=16n nfin=2
MN_q01_fg03 ifg03_q0n ifg03_nai VSS VSS nmos_lvt l=16n nfin=2
MN_q02_fg03 ifg03_q0n ifg03_nbi VSS VSS nmos_lvt l=16n nfin=2
MN_q03_fg03 ifg03_x0 A[6] ifg03_q0n VSS nmos_lvt l=16n nfin=2
MN_q04_fg03 ifg03_x0 B[6] ifg03_q0n VSS nmos_lvt l=16n nfin=2
MP_q11_fg03 ifg03_x1 ifg03_naj ifg03_q1p1 VDD pmos_lvt l=16n nfin=2
MP_q12_fg03 ifg03_q1p1 ifg03_nbj VDD VDD pmos_lvt l=16n nfin=2
MP_q13_fg03 ifg03_x1 A[7] ifg03_q1p2 VDD pmos_lvt l=16n nfin=2
MP_q14_fg03 ifg03_q1p2 B[7] VDD VDD pmos_lvt l=16n nfin=2
MN_q11_fg03 ifg03_q1n ifg03_naj VSS VSS nmos_lvt l=16n nfin=2
MN_q12_fg03 ifg03_q1n ifg03_nbj VSS VSS nmos_lvt l=16n nfin=2
MN_q13_fg03 ifg03_x1 A[7] ifg03_q1n VSS nmos_lvt l=16n nfin=2
MN_q14_fg03 ifg03_x1 B[7] ifg03_q1n VSS nmos_lvt l=16n nfin=2
MN_ix0_fg03 ifg03_d0 ifg03_x0 VSS VSS nmos_lvt l=16n nfin=2
MP_ix0_fg03 ifg03_d0 ifg03_x0 VDD VDD pmos_lvt l=16n nfin=2
MN_ix1_fg03 ifg03_d1 ifg03_x1 VSS VSS nmos_lvt l=16n nfin=2
MP_ix1_fg03 ifg03_d1 ifg03_x1 VDD VDD pmos_lvt l=16n nfin=2
MP_a11_fg03 ifg03_a1p ifg03_d0 VDD VDD pmos_lvt l=16n nfin=2
MP_a12_fg03 ifg03_a1p ifg03_x1 VDD VDD pmos_lvt l=16n nfin=2
MP_a13_fg03 noh1[3] ifg03_x0 ifg03_a1p VDD pmos_lvt l=16n nfin=2
MP_a14_fg03 noh1[3] ifg03_d1 ifg03_a1p VDD pmos_lvt l=16n nfin=2
MN_a11_fg03 noh1[3] ifg03_d0 ifg03_a1n1 VSS nmos_lvt l=16n nfin=2
MN_a12_fg03 ifg03_a1n1 ifg03_x1 VSS VSS nmos_lvt l=16n nfin=2
MN_a13_fg03 noh1[3] ifg03_x0 ifg03_a1n2 VSS nmos_lvt l=16n nfin=2
MN_a14_fg03 ifg03_a1n2 ifg03_d1 VSS VSS nmos_lvt l=16n nfin=2
MP_n21_fg03 noh2[3] ifg03_d0 VDD VDD pmos_lvt l=16n nfin=2
MP_n22_fg03 noh2[3] ifg03_d1 VDD VDD pmos_lvt l=16n nfin=2
MN_n21_fg03 noh2[3] ifg03_d0 ifg03_n2s VSS nmos_lvt l=16n nfin=2
MN_n22_fg03 ifg03_n2s ifg03_d1 VSS VSS nmos_lvt l=16n nfin=2

* FUSED_G fg04 (40T, ASAP5 extracted: W=0.45u L=0.16u)
MN_ifg04_nai ifg04_nai A[8] VSS VSS nmos_lvt l=16n nfin=2
MP_ifg04_nai ifg04_nai A[8] VDD VDD pmos_lvt l=16n nfin=2
MN_ifg04_nbi ifg04_nbi B[8] VSS VSS nmos_lvt l=16n nfin=2
MP_ifg04_nbi ifg04_nbi B[8] VDD VDD pmos_lvt l=16n nfin=2
MN_ifg04_naj ifg04_naj A[9] VSS VSS nmos_lvt l=16n nfin=2
MP_ifg04_naj ifg04_naj A[9] VDD VDD pmos_lvt l=16n nfin=2
MN_ifg04_nbj ifg04_nbj B[9] VSS VSS nmos_lvt l=16n nfin=2
MP_ifg04_nbj ifg04_nbj B[9] VDD VDD pmos_lvt l=16n nfin=2
MP_q01_fg04 ifg04_x0 ifg04_nai ifg04_q0p1 VDD pmos_lvt l=16n nfin=2
MP_q02_fg04 ifg04_q0p1 ifg04_nbi VDD VDD pmos_lvt l=16n nfin=2
MP_q03_fg04 ifg04_x0 A[8] ifg04_q0p2 VDD pmos_lvt l=16n nfin=2
MP_q04_fg04 ifg04_q0p2 B[8] VDD VDD pmos_lvt l=16n nfin=2
MN_q01_fg04 ifg04_q0n ifg04_nai VSS VSS nmos_lvt l=16n nfin=2
MN_q02_fg04 ifg04_q0n ifg04_nbi VSS VSS nmos_lvt l=16n nfin=2
MN_q03_fg04 ifg04_x0 A[8] ifg04_q0n VSS nmos_lvt l=16n nfin=2
MN_q04_fg04 ifg04_x0 B[8] ifg04_q0n VSS nmos_lvt l=16n nfin=2
MP_q11_fg04 ifg04_x1 ifg04_naj ifg04_q1p1 VDD pmos_lvt l=16n nfin=2
MP_q12_fg04 ifg04_q1p1 ifg04_nbj VDD VDD pmos_lvt l=16n nfin=2
MP_q13_fg04 ifg04_x1 A[9] ifg04_q1p2 VDD pmos_lvt l=16n nfin=2
MP_q14_fg04 ifg04_q1p2 B[9] VDD VDD pmos_lvt l=16n nfin=2
MN_q11_fg04 ifg04_q1n ifg04_naj VSS VSS nmos_lvt l=16n nfin=2
MN_q12_fg04 ifg04_q1n ifg04_nbj VSS VSS nmos_lvt l=16n nfin=2
MN_q13_fg04 ifg04_x1 A[9] ifg04_q1n VSS nmos_lvt l=16n nfin=2
MN_q14_fg04 ifg04_x1 B[9] ifg04_q1n VSS nmos_lvt l=16n nfin=2
MN_ix0_fg04 ifg04_d0 ifg04_x0 VSS VSS nmos_lvt l=16n nfin=2
MP_ix0_fg04 ifg04_d0 ifg04_x0 VDD VDD pmos_lvt l=16n nfin=2
MN_ix1_fg04 ifg04_d1 ifg04_x1 VSS VSS nmos_lvt l=16n nfin=2
MP_ix1_fg04 ifg04_d1 ifg04_x1 VDD VDD pmos_lvt l=16n nfin=2
MP_a11_fg04 ifg04_a1p ifg04_d0 VDD VDD pmos_lvt l=16n nfin=2
MP_a12_fg04 ifg04_a1p ifg04_x1 VDD VDD pmos_lvt l=16n nfin=2
MP_a13_fg04 noh1[4] ifg04_x0 ifg04_a1p VDD pmos_lvt l=16n nfin=2
MP_a14_fg04 noh1[4] ifg04_d1 ifg04_a1p VDD pmos_lvt l=16n nfin=2
MN_a11_fg04 noh1[4] ifg04_d0 ifg04_a1n1 VSS nmos_lvt l=16n nfin=2
MN_a12_fg04 ifg04_a1n1 ifg04_x1 VSS VSS nmos_lvt l=16n nfin=2
MN_a13_fg04 noh1[4] ifg04_x0 ifg04_a1n2 VSS nmos_lvt l=16n nfin=2
MN_a14_fg04 ifg04_a1n2 ifg04_d1 VSS VSS nmos_lvt l=16n nfin=2
MP_n21_fg04 noh2[4] ifg04_d0 VDD VDD pmos_lvt l=16n nfin=2
MP_n22_fg04 noh2[4] ifg04_d1 VDD VDD pmos_lvt l=16n nfin=2
MN_n21_fg04 noh2[4] ifg04_d0 ifg04_n2s VSS nmos_lvt l=16n nfin=2
MN_n22_fg04 ifg04_n2s ifg04_d1 VSS VSS nmos_lvt l=16n nfin=2

* FUSED_G fg05 (40T, ASAP5 extracted: W=0.45u L=0.16u)
MN_ifg05_nai ifg05_nai A[10] VSS VSS nmos_lvt l=16n nfin=2
MP_ifg05_nai ifg05_nai A[10] VDD VDD pmos_lvt l=16n nfin=2
MN_ifg05_nbi ifg05_nbi B[10] VSS VSS nmos_lvt l=16n nfin=2
MP_ifg05_nbi ifg05_nbi B[10] VDD VDD pmos_lvt l=16n nfin=2
MN_ifg05_naj ifg05_naj A[11] VSS VSS nmos_lvt l=16n nfin=2
MP_ifg05_naj ifg05_naj A[11] VDD VDD pmos_lvt l=16n nfin=2
MN_ifg05_nbj ifg05_nbj B[11] VSS VSS nmos_lvt l=16n nfin=2
MP_ifg05_nbj ifg05_nbj B[11] VDD VDD pmos_lvt l=16n nfin=2
MP_q01_fg05 ifg05_x0 ifg05_nai ifg05_q0p1 VDD pmos_lvt l=16n nfin=2
MP_q02_fg05 ifg05_q0p1 ifg05_nbi VDD VDD pmos_lvt l=16n nfin=2
MP_q03_fg05 ifg05_x0 A[10] ifg05_q0p2 VDD pmos_lvt l=16n nfin=2
MP_q04_fg05 ifg05_q0p2 B[10] VDD VDD pmos_lvt l=16n nfin=2
MN_q01_fg05 ifg05_q0n ifg05_nai VSS VSS nmos_lvt l=16n nfin=2
MN_q02_fg05 ifg05_q0n ifg05_nbi VSS VSS nmos_lvt l=16n nfin=2
MN_q03_fg05 ifg05_x0 A[10] ifg05_q0n VSS nmos_lvt l=16n nfin=2
MN_q04_fg05 ifg05_x0 B[10] ifg05_q0n VSS nmos_lvt l=16n nfin=2
MP_q11_fg05 ifg05_x1 ifg05_naj ifg05_q1p1 VDD pmos_lvt l=16n nfin=2
MP_q12_fg05 ifg05_q1p1 ifg05_nbj VDD VDD pmos_lvt l=16n nfin=2
MP_q13_fg05 ifg05_x1 A[11] ifg05_q1p2 VDD pmos_lvt l=16n nfin=2
MP_q14_fg05 ifg05_q1p2 B[11] VDD VDD pmos_lvt l=16n nfin=2
MN_q11_fg05 ifg05_q1n ifg05_naj VSS VSS nmos_lvt l=16n nfin=2
MN_q12_fg05 ifg05_q1n ifg05_nbj VSS VSS nmos_lvt l=16n nfin=2
MN_q13_fg05 ifg05_x1 A[11] ifg05_q1n VSS nmos_lvt l=16n nfin=2
MN_q14_fg05 ifg05_x1 B[11] ifg05_q1n VSS nmos_lvt l=16n nfin=2
MN_ix0_fg05 ifg05_d0 ifg05_x0 VSS VSS nmos_lvt l=16n nfin=2
MP_ix0_fg05 ifg05_d0 ifg05_x0 VDD VDD pmos_lvt l=16n nfin=2
MN_ix1_fg05 ifg05_d1 ifg05_x1 VSS VSS nmos_lvt l=16n nfin=2
MP_ix1_fg05 ifg05_d1 ifg05_x1 VDD VDD pmos_lvt l=16n nfin=2
MP_a11_fg05 ifg05_a1p ifg05_d0 VDD VDD pmos_lvt l=16n nfin=2
MP_a12_fg05 ifg05_a1p ifg05_x1 VDD VDD pmos_lvt l=16n nfin=2
MP_a13_fg05 noh1[5] ifg05_x0 ifg05_a1p VDD pmos_lvt l=16n nfin=2
MP_a14_fg05 noh1[5] ifg05_d1 ifg05_a1p VDD pmos_lvt l=16n nfin=2
MN_a11_fg05 noh1[5] ifg05_d0 ifg05_a1n1 VSS nmos_lvt l=16n nfin=2
MN_a12_fg05 ifg05_a1n1 ifg05_x1 VSS VSS nmos_lvt l=16n nfin=2
MN_a13_fg05 noh1[5] ifg05_x0 ifg05_a1n2 VSS nmos_lvt l=16n nfin=2
MN_a14_fg05 ifg05_a1n2 ifg05_d1 VSS VSS nmos_lvt l=16n nfin=2
MP_n21_fg05 noh2[5] ifg05_d0 VDD VDD pmos_lvt l=16n nfin=2
MP_n22_fg05 noh2[5] ifg05_d1 VDD VDD pmos_lvt l=16n nfin=2
MN_n21_fg05 noh2[5] ifg05_d0 ifg05_n2s VSS nmos_lvt l=16n nfin=2
MN_n22_fg05 ifg05_n2s ifg05_d1 VSS VSS nmos_lvt l=16n nfin=2

* FUSED_G fg06 (40T, ASAP5 extracted: W=0.45u L=0.16u)
MN_ifg06_nai ifg06_nai A[12] VSS VSS nmos_lvt l=16n nfin=2
MP_ifg06_nai ifg06_nai A[12] VDD VDD pmos_lvt l=16n nfin=2
MN_ifg06_nbi ifg06_nbi B[12] VSS VSS nmos_lvt l=16n nfin=2
MP_ifg06_nbi ifg06_nbi B[12] VDD VDD pmos_lvt l=16n nfin=2
MN_ifg06_naj ifg06_naj A[13] VSS VSS nmos_lvt l=16n nfin=2
MP_ifg06_naj ifg06_naj A[13] VDD VDD pmos_lvt l=16n nfin=2
MN_ifg06_nbj ifg06_nbj B[13] VSS VSS nmos_lvt l=16n nfin=2
MP_ifg06_nbj ifg06_nbj B[13] VDD VDD pmos_lvt l=16n nfin=2
MP_q01_fg06 ifg06_x0 ifg06_nai ifg06_q0p1 VDD pmos_lvt l=16n nfin=2
MP_q02_fg06 ifg06_q0p1 ifg06_nbi VDD VDD pmos_lvt l=16n nfin=2
MP_q03_fg06 ifg06_x0 A[12] ifg06_q0p2 VDD pmos_lvt l=16n nfin=2
MP_q04_fg06 ifg06_q0p2 B[12] VDD VDD pmos_lvt l=16n nfin=2
MN_q01_fg06 ifg06_q0n ifg06_nai VSS VSS nmos_lvt l=16n nfin=2
MN_q02_fg06 ifg06_q0n ifg06_nbi VSS VSS nmos_lvt l=16n nfin=2
MN_q03_fg06 ifg06_x0 A[12] ifg06_q0n VSS nmos_lvt l=16n nfin=2
MN_q04_fg06 ifg06_x0 B[12] ifg06_q0n VSS nmos_lvt l=16n nfin=2
MP_q11_fg06 ifg06_x1 ifg06_naj ifg06_q1p1 VDD pmos_lvt l=16n nfin=2
MP_q12_fg06 ifg06_q1p1 ifg06_nbj VDD VDD pmos_lvt l=16n nfin=2
MP_q13_fg06 ifg06_x1 A[13] ifg06_q1p2 VDD pmos_lvt l=16n nfin=2
MP_q14_fg06 ifg06_q1p2 B[13] VDD VDD pmos_lvt l=16n nfin=2
MN_q11_fg06 ifg06_q1n ifg06_naj VSS VSS nmos_lvt l=16n nfin=2
MN_q12_fg06 ifg06_q1n ifg06_nbj VSS VSS nmos_lvt l=16n nfin=2
MN_q13_fg06 ifg06_x1 A[13] ifg06_q1n VSS nmos_lvt l=16n nfin=2
MN_q14_fg06 ifg06_x1 B[13] ifg06_q1n VSS nmos_lvt l=16n nfin=2
MN_ix0_fg06 ifg06_d0 ifg06_x0 VSS VSS nmos_lvt l=16n nfin=2
MP_ix0_fg06 ifg06_d0 ifg06_x0 VDD VDD pmos_lvt l=16n nfin=2
MN_ix1_fg06 ifg06_d1 ifg06_x1 VSS VSS nmos_lvt l=16n nfin=2
MP_ix1_fg06 ifg06_d1 ifg06_x1 VDD VDD pmos_lvt l=16n nfin=2
MP_a11_fg06 ifg06_a1p ifg06_d0 VDD VDD pmos_lvt l=16n nfin=2
MP_a12_fg06 ifg06_a1p ifg06_x1 VDD VDD pmos_lvt l=16n nfin=2
MP_a13_fg06 noh1[6] ifg06_x0 ifg06_a1p VDD pmos_lvt l=16n nfin=2
MP_a14_fg06 noh1[6] ifg06_d1 ifg06_a1p VDD pmos_lvt l=16n nfin=2
MN_a11_fg06 noh1[6] ifg06_d0 ifg06_a1n1 VSS nmos_lvt l=16n nfin=2
MN_a12_fg06 ifg06_a1n1 ifg06_x1 VSS VSS nmos_lvt l=16n nfin=2
MN_a13_fg06 noh1[6] ifg06_x0 ifg06_a1n2 VSS nmos_lvt l=16n nfin=2
MN_a14_fg06 ifg06_a1n2 ifg06_d1 VSS VSS nmos_lvt l=16n nfin=2
MP_n21_fg06 noh2[6] ifg06_d0 VDD VDD pmos_lvt l=16n nfin=2
MP_n22_fg06 noh2[6] ifg06_d1 VDD VDD pmos_lvt l=16n nfin=2
MN_n21_fg06 noh2[6] ifg06_d0 ifg06_n2s VSS nmos_lvt l=16n nfin=2
MN_n22_fg06 ifg06_n2s ifg06_d1 VSS VSS nmos_lvt l=16n nfin=2

* FUSED_G fg07 (40T, ASAP5 extracted: W=0.45u L=0.16u)
MN_ifg07_nai ifg07_nai A[14] VSS VSS nmos_lvt l=16n nfin=2
MP_ifg07_nai ifg07_nai A[14] VDD VDD pmos_lvt l=16n nfin=2
MN_ifg07_nbi ifg07_nbi B[14] VSS VSS nmos_lvt l=16n nfin=2
MP_ifg07_nbi ifg07_nbi B[14] VDD VDD pmos_lvt l=16n nfin=2
MN_ifg07_naj ifg07_naj A[15] VSS VSS nmos_lvt l=16n nfin=2
MP_ifg07_naj ifg07_naj A[15] VDD VDD pmos_lvt l=16n nfin=2
MN_ifg07_nbj ifg07_nbj B[15] VSS VSS nmos_lvt l=16n nfin=2
MP_ifg07_nbj ifg07_nbj B[15] VDD VDD pmos_lvt l=16n nfin=2
MP_q01_fg07 ifg07_x0 ifg07_nai ifg07_q0p1 VDD pmos_lvt l=16n nfin=2
MP_q02_fg07 ifg07_q0p1 ifg07_nbi VDD VDD pmos_lvt l=16n nfin=2
MP_q03_fg07 ifg07_x0 A[14] ifg07_q0p2 VDD pmos_lvt l=16n nfin=2
MP_q04_fg07 ifg07_q0p2 B[14] VDD VDD pmos_lvt l=16n nfin=2
MN_q01_fg07 ifg07_q0n ifg07_nai VSS VSS nmos_lvt l=16n nfin=2
MN_q02_fg07 ifg07_q0n ifg07_nbi VSS VSS nmos_lvt l=16n nfin=2
MN_q03_fg07 ifg07_x0 A[14] ifg07_q0n VSS nmos_lvt l=16n nfin=2
MN_q04_fg07 ifg07_x0 B[14] ifg07_q0n VSS nmos_lvt l=16n nfin=2
MP_q11_fg07 ifg07_x1 ifg07_naj ifg07_q1p1 VDD pmos_lvt l=16n nfin=2
MP_q12_fg07 ifg07_q1p1 ifg07_nbj VDD VDD pmos_lvt l=16n nfin=2
MP_q13_fg07 ifg07_x1 A[15] ifg07_q1p2 VDD pmos_lvt l=16n nfin=2
MP_q14_fg07 ifg07_q1p2 B[15] VDD VDD pmos_lvt l=16n nfin=2
MN_q11_fg07 ifg07_q1n ifg07_naj VSS VSS nmos_lvt l=16n nfin=2
MN_q12_fg07 ifg07_q1n ifg07_nbj VSS VSS nmos_lvt l=16n nfin=2
MN_q13_fg07 ifg07_x1 A[15] ifg07_q1n VSS nmos_lvt l=16n nfin=2
MN_q14_fg07 ifg07_x1 B[15] ifg07_q1n VSS nmos_lvt l=16n nfin=2
MN_ix0_fg07 ifg07_d0 ifg07_x0 VSS VSS nmos_lvt l=16n nfin=2
MP_ix0_fg07 ifg07_d0 ifg07_x0 VDD VDD pmos_lvt l=16n nfin=2
MN_ix1_fg07 ifg07_d1 ifg07_x1 VSS VSS nmos_lvt l=16n nfin=2
MP_ix1_fg07 ifg07_d1 ifg07_x1 VDD VDD pmos_lvt l=16n nfin=2
MP_a11_fg07 ifg07_a1p ifg07_d0 VDD VDD pmos_lvt l=16n nfin=2
MP_a12_fg07 ifg07_a1p ifg07_x1 VDD VDD pmos_lvt l=16n nfin=2
MP_a13_fg07 noh1[7] ifg07_x0 ifg07_a1p VDD pmos_lvt l=16n nfin=2
MP_a14_fg07 noh1[7] ifg07_d1 ifg07_a1p VDD pmos_lvt l=16n nfin=2
MN_a11_fg07 noh1[7] ifg07_d0 ifg07_a1n1 VSS nmos_lvt l=16n nfin=2
MN_a12_fg07 ifg07_a1n1 ifg07_x1 VSS VSS nmos_lvt l=16n nfin=2
MN_a13_fg07 noh1[7] ifg07_x0 ifg07_a1n2 VSS nmos_lvt l=16n nfin=2
MN_a14_fg07 ifg07_a1n2 ifg07_d1 VSS VSS nmos_lvt l=16n nfin=2
MP_n21_fg07 noh2[7] ifg07_d0 VDD VDD pmos_lvt l=16n nfin=2
MP_n22_fg07 noh2[7] ifg07_d1 VDD VDD pmos_lvt l=16n nfin=2
MN_n21_fg07 noh2[7] ifg07_d0 ifg07_n2s VSS nmos_lvt l=16n nfin=2
MN_n22_fg07 ifg07_n2s ifg07_d1 VSS VSS nmos_lvt l=16n nfin=2

* FUSED_G fg08 (40T, ASAP5 extracted: W=0.45u L=0.16u)
MN_ifg08_nai ifg08_nai A[16] VSS VSS nmos_lvt l=16n nfin=2
MP_ifg08_nai ifg08_nai A[16] VDD VDD pmos_lvt l=16n nfin=2
MN_ifg08_nbi ifg08_nbi B[16] VSS VSS nmos_lvt l=16n nfin=2
MP_ifg08_nbi ifg08_nbi B[16] VDD VDD pmos_lvt l=16n nfin=2
MN_ifg08_naj ifg08_naj A[17] VSS VSS nmos_lvt l=16n nfin=2
MP_ifg08_naj ifg08_naj A[17] VDD VDD pmos_lvt l=16n nfin=2
MN_ifg08_nbj ifg08_nbj B[17] VSS VSS nmos_lvt l=16n nfin=2
MP_ifg08_nbj ifg08_nbj B[17] VDD VDD pmos_lvt l=16n nfin=2
MP_q01_fg08 ifg08_x0 ifg08_nai ifg08_q0p1 VDD pmos_lvt l=16n nfin=2
MP_q02_fg08 ifg08_q0p1 ifg08_nbi VDD VDD pmos_lvt l=16n nfin=2
MP_q03_fg08 ifg08_x0 A[16] ifg08_q0p2 VDD pmos_lvt l=16n nfin=2
MP_q04_fg08 ifg08_q0p2 B[16] VDD VDD pmos_lvt l=16n nfin=2
MN_q01_fg08 ifg08_q0n ifg08_nai VSS VSS nmos_lvt l=16n nfin=2
MN_q02_fg08 ifg08_q0n ifg08_nbi VSS VSS nmos_lvt l=16n nfin=2
MN_q03_fg08 ifg08_x0 A[16] ifg08_q0n VSS nmos_lvt l=16n nfin=2
MN_q04_fg08 ifg08_x0 B[16] ifg08_q0n VSS nmos_lvt l=16n nfin=2
MP_q11_fg08 ifg08_x1 ifg08_naj ifg08_q1p1 VDD pmos_lvt l=16n nfin=2
MP_q12_fg08 ifg08_q1p1 ifg08_nbj VDD VDD pmos_lvt l=16n nfin=2
MP_q13_fg08 ifg08_x1 A[17] ifg08_q1p2 VDD pmos_lvt l=16n nfin=2
MP_q14_fg08 ifg08_q1p2 B[17] VDD VDD pmos_lvt l=16n nfin=2
MN_q11_fg08 ifg08_q1n ifg08_naj VSS VSS nmos_lvt l=16n nfin=2
MN_q12_fg08 ifg08_q1n ifg08_nbj VSS VSS nmos_lvt l=16n nfin=2
MN_q13_fg08 ifg08_x1 A[17] ifg08_q1n VSS nmos_lvt l=16n nfin=2
MN_q14_fg08 ifg08_x1 B[17] ifg08_q1n VSS nmos_lvt l=16n nfin=2
MN_ix0_fg08 ifg08_d0 ifg08_x0 VSS VSS nmos_lvt l=16n nfin=2
MP_ix0_fg08 ifg08_d0 ifg08_x0 VDD VDD pmos_lvt l=16n nfin=2
MN_ix1_fg08 ifg08_d1 ifg08_x1 VSS VSS nmos_lvt l=16n nfin=2
MP_ix1_fg08 ifg08_d1 ifg08_x1 VDD VDD pmos_lvt l=16n nfin=2
MP_a11_fg08 ifg08_a1p ifg08_d0 VDD VDD pmos_lvt l=16n nfin=2
MP_a12_fg08 ifg08_a1p ifg08_x1 VDD VDD pmos_lvt l=16n nfin=2
MP_a13_fg08 noh1[8] ifg08_x0 ifg08_a1p VDD pmos_lvt l=16n nfin=2
MP_a14_fg08 noh1[8] ifg08_d1 ifg08_a1p VDD pmos_lvt l=16n nfin=2
MN_a11_fg08 noh1[8] ifg08_d0 ifg08_a1n1 VSS nmos_lvt l=16n nfin=2
MN_a12_fg08 ifg08_a1n1 ifg08_x1 VSS VSS nmos_lvt l=16n nfin=2
MN_a13_fg08 noh1[8] ifg08_x0 ifg08_a1n2 VSS nmos_lvt l=16n nfin=2
MN_a14_fg08 ifg08_a1n2 ifg08_d1 VSS VSS nmos_lvt l=16n nfin=2
MP_n21_fg08 noh2[8] ifg08_d0 VDD VDD pmos_lvt l=16n nfin=2
MP_n22_fg08 noh2[8] ifg08_d1 VDD VDD pmos_lvt l=16n nfin=2
MN_n21_fg08 noh2[8] ifg08_d0 ifg08_n2s VSS nmos_lvt l=16n nfin=2
MN_n22_fg08 ifg08_n2s ifg08_d1 VSS VSS nmos_lvt l=16n nfin=2

* FUSED_G fg09 (40T, ASAP5 extracted: W=0.45u L=0.16u)
MN_ifg09_nai ifg09_nai A[18] VSS VSS nmos_lvt l=16n nfin=2
MP_ifg09_nai ifg09_nai A[18] VDD VDD pmos_lvt l=16n nfin=2
MN_ifg09_nbi ifg09_nbi B[18] VSS VSS nmos_lvt l=16n nfin=2
MP_ifg09_nbi ifg09_nbi B[18] VDD VDD pmos_lvt l=16n nfin=2
MN_ifg09_naj ifg09_naj A[19] VSS VSS nmos_lvt l=16n nfin=2
MP_ifg09_naj ifg09_naj A[19] VDD VDD pmos_lvt l=16n nfin=2
MN_ifg09_nbj ifg09_nbj B[19] VSS VSS nmos_lvt l=16n nfin=2
MP_ifg09_nbj ifg09_nbj B[19] VDD VDD pmos_lvt l=16n nfin=2
MP_q01_fg09 ifg09_x0 ifg09_nai ifg09_q0p1 VDD pmos_lvt l=16n nfin=2
MP_q02_fg09 ifg09_q0p1 ifg09_nbi VDD VDD pmos_lvt l=16n nfin=2
MP_q03_fg09 ifg09_x0 A[18] ifg09_q0p2 VDD pmos_lvt l=16n nfin=2
MP_q04_fg09 ifg09_q0p2 B[18] VDD VDD pmos_lvt l=16n nfin=2
MN_q01_fg09 ifg09_q0n ifg09_nai VSS VSS nmos_lvt l=16n nfin=2
MN_q02_fg09 ifg09_q0n ifg09_nbi VSS VSS nmos_lvt l=16n nfin=2
MN_q03_fg09 ifg09_x0 A[18] ifg09_q0n VSS nmos_lvt l=16n nfin=2
MN_q04_fg09 ifg09_x0 B[18] ifg09_q0n VSS nmos_lvt l=16n nfin=2
MP_q11_fg09 ifg09_x1 ifg09_naj ifg09_q1p1 VDD pmos_lvt l=16n nfin=2
MP_q12_fg09 ifg09_q1p1 ifg09_nbj VDD VDD pmos_lvt l=16n nfin=2
MP_q13_fg09 ifg09_x1 A[19] ifg09_q1p2 VDD pmos_lvt l=16n nfin=2
MP_q14_fg09 ifg09_q1p2 B[19] VDD VDD pmos_lvt l=16n nfin=2
MN_q11_fg09 ifg09_q1n ifg09_naj VSS VSS nmos_lvt l=16n nfin=2
MN_q12_fg09 ifg09_q1n ifg09_nbj VSS VSS nmos_lvt l=16n nfin=2
MN_q13_fg09 ifg09_x1 A[19] ifg09_q1n VSS nmos_lvt l=16n nfin=2
MN_q14_fg09 ifg09_x1 B[19] ifg09_q1n VSS nmos_lvt l=16n nfin=2
MN_ix0_fg09 ifg09_d0 ifg09_x0 VSS VSS nmos_lvt l=16n nfin=2
MP_ix0_fg09 ifg09_d0 ifg09_x0 VDD VDD pmos_lvt l=16n nfin=2
MN_ix1_fg09 ifg09_d1 ifg09_x1 VSS VSS nmos_lvt l=16n nfin=2
MP_ix1_fg09 ifg09_d1 ifg09_x1 VDD VDD pmos_lvt l=16n nfin=2
MP_a11_fg09 ifg09_a1p ifg09_d0 VDD VDD pmos_lvt l=16n nfin=2
MP_a12_fg09 ifg09_a1p ifg09_x1 VDD VDD pmos_lvt l=16n nfin=2
MP_a13_fg09 noh1[9] ifg09_x0 ifg09_a1p VDD pmos_lvt l=16n nfin=2
MP_a14_fg09 noh1[9] ifg09_d1 ifg09_a1p VDD pmos_lvt l=16n nfin=2
MN_a11_fg09 noh1[9] ifg09_d0 ifg09_a1n1 VSS nmos_lvt l=16n nfin=2
MN_a12_fg09 ifg09_a1n1 ifg09_x1 VSS VSS nmos_lvt l=16n nfin=2
MN_a13_fg09 noh1[9] ifg09_x0 ifg09_a1n2 VSS nmos_lvt l=16n nfin=2
MN_a14_fg09 ifg09_a1n2 ifg09_d1 VSS VSS nmos_lvt l=16n nfin=2
MP_n21_fg09 noh2[9] ifg09_d0 VDD VDD pmos_lvt l=16n nfin=2
MP_n22_fg09 noh2[9] ifg09_d1 VDD VDD pmos_lvt l=16n nfin=2
MN_n21_fg09 noh2[9] ifg09_d0 ifg09_n2s VSS nmos_lvt l=16n nfin=2
MN_n22_fg09 ifg09_n2s ifg09_d1 VSS VSS nmos_lvt l=16n nfin=2

* FUSED_G fg10 (40T, ASAP5 extracted: W=0.45u L=0.16u)
MN_ifg10_nai ifg10_nai A[20] VSS VSS nmos_lvt l=16n nfin=2
MP_ifg10_nai ifg10_nai A[20] VDD VDD pmos_lvt l=16n nfin=2
MN_ifg10_nbi ifg10_nbi B[20] VSS VSS nmos_lvt l=16n nfin=2
MP_ifg10_nbi ifg10_nbi B[20] VDD VDD pmos_lvt l=16n nfin=2
MN_ifg10_naj ifg10_naj A[21] VSS VSS nmos_lvt l=16n nfin=2
MP_ifg10_naj ifg10_naj A[21] VDD VDD pmos_lvt l=16n nfin=2
MN_ifg10_nbj ifg10_nbj B[21] VSS VSS nmos_lvt l=16n nfin=2
MP_ifg10_nbj ifg10_nbj B[21] VDD VDD pmos_lvt l=16n nfin=2
MP_q01_fg10 ifg10_x0 ifg10_nai ifg10_q0p1 VDD pmos_lvt l=16n nfin=2
MP_q02_fg10 ifg10_q0p1 ifg10_nbi VDD VDD pmos_lvt l=16n nfin=2
MP_q03_fg10 ifg10_x0 A[20] ifg10_q0p2 VDD pmos_lvt l=16n nfin=2
MP_q04_fg10 ifg10_q0p2 B[20] VDD VDD pmos_lvt l=16n nfin=2
MN_q01_fg10 ifg10_q0n ifg10_nai VSS VSS nmos_lvt l=16n nfin=2
MN_q02_fg10 ifg10_q0n ifg10_nbi VSS VSS nmos_lvt l=16n nfin=2
MN_q03_fg10 ifg10_x0 A[20] ifg10_q0n VSS nmos_lvt l=16n nfin=2
MN_q04_fg10 ifg10_x0 B[20] ifg10_q0n VSS nmos_lvt l=16n nfin=2
MP_q11_fg10 ifg10_x1 ifg10_naj ifg10_q1p1 VDD pmos_lvt l=16n nfin=2
MP_q12_fg10 ifg10_q1p1 ifg10_nbj VDD VDD pmos_lvt l=16n nfin=2
MP_q13_fg10 ifg10_x1 A[21] ifg10_q1p2 VDD pmos_lvt l=16n nfin=2
MP_q14_fg10 ifg10_q1p2 B[21] VDD VDD pmos_lvt l=16n nfin=2
MN_q11_fg10 ifg10_q1n ifg10_naj VSS VSS nmos_lvt l=16n nfin=2
MN_q12_fg10 ifg10_q1n ifg10_nbj VSS VSS nmos_lvt l=16n nfin=2
MN_q13_fg10 ifg10_x1 A[21] ifg10_q1n VSS nmos_lvt l=16n nfin=2
MN_q14_fg10 ifg10_x1 B[21] ifg10_q1n VSS nmos_lvt l=16n nfin=2
MN_ix0_fg10 ifg10_d0 ifg10_x0 VSS VSS nmos_lvt l=16n nfin=2
MP_ix0_fg10 ifg10_d0 ifg10_x0 VDD VDD pmos_lvt l=16n nfin=2
MN_ix1_fg10 ifg10_d1 ifg10_x1 VSS VSS nmos_lvt l=16n nfin=2
MP_ix1_fg10 ifg10_d1 ifg10_x1 VDD VDD pmos_lvt l=16n nfin=2
MP_a11_fg10 ifg10_a1p ifg10_d0 VDD VDD pmos_lvt l=16n nfin=2
MP_a12_fg10 ifg10_a1p ifg10_x1 VDD VDD pmos_lvt l=16n nfin=2
MP_a13_fg10 noh1[10] ifg10_x0 ifg10_a1p VDD pmos_lvt l=16n nfin=2
MP_a14_fg10 noh1[10] ifg10_d1 ifg10_a1p VDD pmos_lvt l=16n nfin=2
MN_a11_fg10 noh1[10] ifg10_d0 ifg10_a1n1 VSS nmos_lvt l=16n nfin=2
MN_a12_fg10 ifg10_a1n1 ifg10_x1 VSS VSS nmos_lvt l=16n nfin=2
MN_a13_fg10 noh1[10] ifg10_x0 ifg10_a1n2 VSS nmos_lvt l=16n nfin=2
MN_a14_fg10 ifg10_a1n2 ifg10_d1 VSS VSS nmos_lvt l=16n nfin=2
MP_n21_fg10 noh2[10] ifg10_d0 VDD VDD pmos_lvt l=16n nfin=2
MP_n22_fg10 noh2[10] ifg10_d1 VDD VDD pmos_lvt l=16n nfin=2
MN_n21_fg10 noh2[10] ifg10_d0 ifg10_n2s VSS nmos_lvt l=16n nfin=2
MN_n22_fg10 ifg10_n2s ifg10_d1 VSS VSS nmos_lvt l=16n nfin=2

* FUSED_G fg11 (40T, ASAP5 extracted: W=0.45u L=0.16u)
MN_ifg11_nai ifg11_nai A[22] VSS VSS nmos_lvt l=16n nfin=2
MP_ifg11_nai ifg11_nai A[22] VDD VDD pmos_lvt l=16n nfin=2
MN_ifg11_nbi ifg11_nbi B[22] VSS VSS nmos_lvt l=16n nfin=2
MP_ifg11_nbi ifg11_nbi B[22] VDD VDD pmos_lvt l=16n nfin=2
MN_ifg11_naj ifg11_naj A[23] VSS VSS nmos_lvt l=16n nfin=2
MP_ifg11_naj ifg11_naj A[23] VDD VDD pmos_lvt l=16n nfin=2
MN_ifg11_nbj ifg11_nbj B[23] VSS VSS nmos_lvt l=16n nfin=2
MP_ifg11_nbj ifg11_nbj B[23] VDD VDD pmos_lvt l=16n nfin=2
MP_q01_fg11 ifg11_x0 ifg11_nai ifg11_q0p1 VDD pmos_lvt l=16n nfin=2
MP_q02_fg11 ifg11_q0p1 ifg11_nbi VDD VDD pmos_lvt l=16n nfin=2
MP_q03_fg11 ifg11_x0 A[22] ifg11_q0p2 VDD pmos_lvt l=16n nfin=2
MP_q04_fg11 ifg11_q0p2 B[22] VDD VDD pmos_lvt l=16n nfin=2
MN_q01_fg11 ifg11_q0n ifg11_nai VSS VSS nmos_lvt l=16n nfin=2
MN_q02_fg11 ifg11_q0n ifg11_nbi VSS VSS nmos_lvt l=16n nfin=2
MN_q03_fg11 ifg11_x0 A[22] ifg11_q0n VSS nmos_lvt l=16n nfin=2
MN_q04_fg11 ifg11_x0 B[22] ifg11_q0n VSS nmos_lvt l=16n nfin=2
MP_q11_fg11 ifg11_x1 ifg11_naj ifg11_q1p1 VDD pmos_lvt l=16n nfin=2
MP_q12_fg11 ifg11_q1p1 ifg11_nbj VDD VDD pmos_lvt l=16n nfin=2
MP_q13_fg11 ifg11_x1 A[23] ifg11_q1p2 VDD pmos_lvt l=16n nfin=2
MP_q14_fg11 ifg11_q1p2 B[23] VDD VDD pmos_lvt l=16n nfin=2
MN_q11_fg11 ifg11_q1n ifg11_naj VSS VSS nmos_lvt l=16n nfin=2
MN_q12_fg11 ifg11_q1n ifg11_nbj VSS VSS nmos_lvt l=16n nfin=2
MN_q13_fg11 ifg11_x1 A[23] ifg11_q1n VSS nmos_lvt l=16n nfin=2
MN_q14_fg11 ifg11_x1 B[23] ifg11_q1n VSS nmos_lvt l=16n nfin=2
MN_ix0_fg11 ifg11_d0 ifg11_x0 VSS VSS nmos_lvt l=16n nfin=2
MP_ix0_fg11 ifg11_d0 ifg11_x0 VDD VDD pmos_lvt l=16n nfin=2
MN_ix1_fg11 ifg11_d1 ifg11_x1 VSS VSS nmos_lvt l=16n nfin=2
MP_ix1_fg11 ifg11_d1 ifg11_x1 VDD VDD pmos_lvt l=16n nfin=2
MP_a11_fg11 ifg11_a1p ifg11_d0 VDD VDD pmos_lvt l=16n nfin=2
MP_a12_fg11 ifg11_a1p ifg11_x1 VDD VDD pmos_lvt l=16n nfin=2
MP_a13_fg11 noh1[11] ifg11_x0 ifg11_a1p VDD pmos_lvt l=16n nfin=2
MP_a14_fg11 noh1[11] ifg11_d1 ifg11_a1p VDD pmos_lvt l=16n nfin=2
MN_a11_fg11 noh1[11] ifg11_d0 ifg11_a1n1 VSS nmos_lvt l=16n nfin=2
MN_a12_fg11 ifg11_a1n1 ifg11_x1 VSS VSS nmos_lvt l=16n nfin=2
MN_a13_fg11 noh1[11] ifg11_x0 ifg11_a1n2 VSS nmos_lvt l=16n nfin=2
MN_a14_fg11 ifg11_a1n2 ifg11_d1 VSS VSS nmos_lvt l=16n nfin=2
MP_n21_fg11 noh2[11] ifg11_d0 VDD VDD pmos_lvt l=16n nfin=2
MP_n22_fg11 noh2[11] ifg11_d1 VDD VDD pmos_lvt l=16n nfin=2
MN_n21_fg11 noh2[11] ifg11_d0 ifg11_n2s VSS nmos_lvt l=16n nfin=2
MN_n22_fg11 ifg11_n2s ifg11_d1 VSS VSS nmos_lvt l=16n nfin=2

* FUSED_G fg12 (40T, ASAP5 extracted: W=0.45u L=0.16u)
MN_ifg12_nai ifg12_nai A[24] VSS VSS nmos_lvt l=16n nfin=2
MP_ifg12_nai ifg12_nai A[24] VDD VDD pmos_lvt l=16n nfin=2
MN_ifg12_nbi ifg12_nbi B[24] VSS VSS nmos_lvt l=16n nfin=2
MP_ifg12_nbi ifg12_nbi B[24] VDD VDD pmos_lvt l=16n nfin=2
MN_ifg12_naj ifg12_naj A[25] VSS VSS nmos_lvt l=16n nfin=2
MP_ifg12_naj ifg12_naj A[25] VDD VDD pmos_lvt l=16n nfin=2
MN_ifg12_nbj ifg12_nbj B[25] VSS VSS nmos_lvt l=16n nfin=2
MP_ifg12_nbj ifg12_nbj B[25] VDD VDD pmos_lvt l=16n nfin=2
MP_q01_fg12 ifg12_x0 ifg12_nai ifg12_q0p1 VDD pmos_lvt l=16n nfin=2
MP_q02_fg12 ifg12_q0p1 ifg12_nbi VDD VDD pmos_lvt l=16n nfin=2
MP_q03_fg12 ifg12_x0 A[24] ifg12_q0p2 VDD pmos_lvt l=16n nfin=2
MP_q04_fg12 ifg12_q0p2 B[24] VDD VDD pmos_lvt l=16n nfin=2
MN_q01_fg12 ifg12_q0n ifg12_nai VSS VSS nmos_lvt l=16n nfin=2
MN_q02_fg12 ifg12_q0n ifg12_nbi VSS VSS nmos_lvt l=16n nfin=2
MN_q03_fg12 ifg12_x0 A[24] ifg12_q0n VSS nmos_lvt l=16n nfin=2
MN_q04_fg12 ifg12_x0 B[24] ifg12_q0n VSS nmos_lvt l=16n nfin=2
MP_q11_fg12 ifg12_x1 ifg12_naj ifg12_q1p1 VDD pmos_lvt l=16n nfin=2
MP_q12_fg12 ifg12_q1p1 ifg12_nbj VDD VDD pmos_lvt l=16n nfin=2
MP_q13_fg12 ifg12_x1 A[25] ifg12_q1p2 VDD pmos_lvt l=16n nfin=2
MP_q14_fg12 ifg12_q1p2 B[25] VDD VDD pmos_lvt l=16n nfin=2
MN_q11_fg12 ifg12_q1n ifg12_naj VSS VSS nmos_lvt l=16n nfin=2
MN_q12_fg12 ifg12_q1n ifg12_nbj VSS VSS nmos_lvt l=16n nfin=2
MN_q13_fg12 ifg12_x1 A[25] ifg12_q1n VSS nmos_lvt l=16n nfin=2
MN_q14_fg12 ifg12_x1 B[25] ifg12_q1n VSS nmos_lvt l=16n nfin=2
MN_ix0_fg12 ifg12_d0 ifg12_x0 VSS VSS nmos_lvt l=16n nfin=2
MP_ix0_fg12 ifg12_d0 ifg12_x0 VDD VDD pmos_lvt l=16n nfin=2
MN_ix1_fg12 ifg12_d1 ifg12_x1 VSS VSS nmos_lvt l=16n nfin=2
MP_ix1_fg12 ifg12_d1 ifg12_x1 VDD VDD pmos_lvt l=16n nfin=2
MP_a11_fg12 ifg12_a1p ifg12_d0 VDD VDD pmos_lvt l=16n nfin=2
MP_a12_fg12 ifg12_a1p ifg12_x1 VDD VDD pmos_lvt l=16n nfin=2
MP_a13_fg12 noh1[12] ifg12_x0 ifg12_a1p VDD pmos_lvt l=16n nfin=2
MP_a14_fg12 noh1[12] ifg12_d1 ifg12_a1p VDD pmos_lvt l=16n nfin=2
MN_a11_fg12 noh1[12] ifg12_d0 ifg12_a1n1 VSS nmos_lvt l=16n nfin=2
MN_a12_fg12 ifg12_a1n1 ifg12_x1 VSS VSS nmos_lvt l=16n nfin=2
MN_a13_fg12 noh1[12] ifg12_x0 ifg12_a1n2 VSS nmos_lvt l=16n nfin=2
MN_a14_fg12 ifg12_a1n2 ifg12_d1 VSS VSS nmos_lvt l=16n nfin=2
MP_n21_fg12 noh2[12] ifg12_d0 VDD VDD pmos_lvt l=16n nfin=2
MP_n22_fg12 noh2[12] ifg12_d1 VDD VDD pmos_lvt l=16n nfin=2
MN_n21_fg12 noh2[12] ifg12_d0 ifg12_n2s VSS nmos_lvt l=16n nfin=2
MN_n22_fg12 ifg12_n2s ifg12_d1 VSS VSS nmos_lvt l=16n nfin=2

* FUSED_G fg13 (40T, ASAP5 extracted: W=0.45u L=0.16u)
MN_ifg13_nai ifg13_nai A[26] VSS VSS nmos_lvt l=16n nfin=2
MP_ifg13_nai ifg13_nai A[26] VDD VDD pmos_lvt l=16n nfin=2
MN_ifg13_nbi ifg13_nbi B[26] VSS VSS nmos_lvt l=16n nfin=2
MP_ifg13_nbi ifg13_nbi B[26] VDD VDD pmos_lvt l=16n nfin=2
MN_ifg13_naj ifg13_naj A[27] VSS VSS nmos_lvt l=16n nfin=2
MP_ifg13_naj ifg13_naj A[27] VDD VDD pmos_lvt l=16n nfin=2
MN_ifg13_nbj ifg13_nbj B[27] VSS VSS nmos_lvt l=16n nfin=2
MP_ifg13_nbj ifg13_nbj B[27] VDD VDD pmos_lvt l=16n nfin=2
MP_q01_fg13 ifg13_x0 ifg13_nai ifg13_q0p1 VDD pmos_lvt l=16n nfin=2
MP_q02_fg13 ifg13_q0p1 ifg13_nbi VDD VDD pmos_lvt l=16n nfin=2
MP_q03_fg13 ifg13_x0 A[26] ifg13_q0p2 VDD pmos_lvt l=16n nfin=2
MP_q04_fg13 ifg13_q0p2 B[26] VDD VDD pmos_lvt l=16n nfin=2
MN_q01_fg13 ifg13_q0n ifg13_nai VSS VSS nmos_lvt l=16n nfin=2
MN_q02_fg13 ifg13_q0n ifg13_nbi VSS VSS nmos_lvt l=16n nfin=2
MN_q03_fg13 ifg13_x0 A[26] ifg13_q0n VSS nmos_lvt l=16n nfin=2
MN_q04_fg13 ifg13_x0 B[26] ifg13_q0n VSS nmos_lvt l=16n nfin=2
MP_q11_fg13 ifg13_x1 ifg13_naj ifg13_q1p1 VDD pmos_lvt l=16n nfin=2
MP_q12_fg13 ifg13_q1p1 ifg13_nbj VDD VDD pmos_lvt l=16n nfin=2
MP_q13_fg13 ifg13_x1 A[27] ifg13_q1p2 VDD pmos_lvt l=16n nfin=2
MP_q14_fg13 ifg13_q1p2 B[27] VDD VDD pmos_lvt l=16n nfin=2
MN_q11_fg13 ifg13_q1n ifg13_naj VSS VSS nmos_lvt l=16n nfin=2
MN_q12_fg13 ifg13_q1n ifg13_nbj VSS VSS nmos_lvt l=16n nfin=2
MN_q13_fg13 ifg13_x1 A[27] ifg13_q1n VSS nmos_lvt l=16n nfin=2
MN_q14_fg13 ifg13_x1 B[27] ifg13_q1n VSS nmos_lvt l=16n nfin=2
MN_ix0_fg13 ifg13_d0 ifg13_x0 VSS VSS nmos_lvt l=16n nfin=2
MP_ix0_fg13 ifg13_d0 ifg13_x0 VDD VDD pmos_lvt l=16n nfin=2
MN_ix1_fg13 ifg13_d1 ifg13_x1 VSS VSS nmos_lvt l=16n nfin=2
MP_ix1_fg13 ifg13_d1 ifg13_x1 VDD VDD pmos_lvt l=16n nfin=2
MP_a11_fg13 ifg13_a1p ifg13_d0 VDD VDD pmos_lvt l=16n nfin=2
MP_a12_fg13 ifg13_a1p ifg13_x1 VDD VDD pmos_lvt l=16n nfin=2
MP_a13_fg13 noh1[13] ifg13_x0 ifg13_a1p VDD pmos_lvt l=16n nfin=2
MP_a14_fg13 noh1[13] ifg13_d1 ifg13_a1p VDD pmos_lvt l=16n nfin=2
MN_a11_fg13 noh1[13] ifg13_d0 ifg13_a1n1 VSS nmos_lvt l=16n nfin=2
MN_a12_fg13 ifg13_a1n1 ifg13_x1 VSS VSS nmos_lvt l=16n nfin=2
MN_a13_fg13 noh1[13] ifg13_x0 ifg13_a1n2 VSS nmos_lvt l=16n nfin=2
MN_a14_fg13 ifg13_a1n2 ifg13_d1 VSS VSS nmos_lvt l=16n nfin=2
MP_n21_fg13 noh2[13] ifg13_d0 VDD VDD pmos_lvt l=16n nfin=2
MP_n22_fg13 noh2[13] ifg13_d1 VDD VDD pmos_lvt l=16n nfin=2
MN_n21_fg13 noh2[13] ifg13_d0 ifg13_n2s VSS nmos_lvt l=16n nfin=2
MN_n22_fg13 ifg13_n2s ifg13_d1 VSS VSS nmos_lvt l=16n nfin=2

* FUSED_G fg14 (40T, ASAP5 extracted: W=0.45u L=0.16u)
MN_ifg14_nai ifg14_nai A[28] VSS VSS nmos_lvt l=16n nfin=2
MP_ifg14_nai ifg14_nai A[28] VDD VDD pmos_lvt l=16n nfin=2
MN_ifg14_nbi ifg14_nbi B[28] VSS VSS nmos_lvt l=16n nfin=2
MP_ifg14_nbi ifg14_nbi B[28] VDD VDD pmos_lvt l=16n nfin=2
MN_ifg14_naj ifg14_naj A[29] VSS VSS nmos_lvt l=16n nfin=2
MP_ifg14_naj ifg14_naj A[29] VDD VDD pmos_lvt l=16n nfin=2
MN_ifg14_nbj ifg14_nbj B[29] VSS VSS nmos_lvt l=16n nfin=2
MP_ifg14_nbj ifg14_nbj B[29] VDD VDD pmos_lvt l=16n nfin=2
MP_q01_fg14 ifg14_x0 ifg14_nai ifg14_q0p1 VDD pmos_lvt l=16n nfin=2
MP_q02_fg14 ifg14_q0p1 ifg14_nbi VDD VDD pmos_lvt l=16n nfin=2
MP_q03_fg14 ifg14_x0 A[28] ifg14_q0p2 VDD pmos_lvt l=16n nfin=2
MP_q04_fg14 ifg14_q0p2 B[28] VDD VDD pmos_lvt l=16n nfin=2
MN_q01_fg14 ifg14_q0n ifg14_nai VSS VSS nmos_lvt l=16n nfin=2
MN_q02_fg14 ifg14_q0n ifg14_nbi VSS VSS nmos_lvt l=16n nfin=2
MN_q03_fg14 ifg14_x0 A[28] ifg14_q0n VSS nmos_lvt l=16n nfin=2
MN_q04_fg14 ifg14_x0 B[28] ifg14_q0n VSS nmos_lvt l=16n nfin=2
MP_q11_fg14 ifg14_x1 ifg14_naj ifg14_q1p1 VDD pmos_lvt l=16n nfin=2
MP_q12_fg14 ifg14_q1p1 ifg14_nbj VDD VDD pmos_lvt l=16n nfin=2
MP_q13_fg14 ifg14_x1 A[29] ifg14_q1p2 VDD pmos_lvt l=16n nfin=2
MP_q14_fg14 ifg14_q1p2 B[29] VDD VDD pmos_lvt l=16n nfin=2
MN_q11_fg14 ifg14_q1n ifg14_naj VSS VSS nmos_lvt l=16n nfin=2
MN_q12_fg14 ifg14_q1n ifg14_nbj VSS VSS nmos_lvt l=16n nfin=2
MN_q13_fg14 ifg14_x1 A[29] ifg14_q1n VSS nmos_lvt l=16n nfin=2
MN_q14_fg14 ifg14_x1 B[29] ifg14_q1n VSS nmos_lvt l=16n nfin=2
MN_ix0_fg14 ifg14_d0 ifg14_x0 VSS VSS nmos_lvt l=16n nfin=2
MP_ix0_fg14 ifg14_d0 ifg14_x0 VDD VDD pmos_lvt l=16n nfin=2
MN_ix1_fg14 ifg14_d1 ifg14_x1 VSS VSS nmos_lvt l=16n nfin=2
MP_ix1_fg14 ifg14_d1 ifg14_x1 VDD VDD pmos_lvt l=16n nfin=2
MP_a11_fg14 ifg14_a1p ifg14_d0 VDD VDD pmos_lvt l=16n nfin=2
MP_a12_fg14 ifg14_a1p ifg14_x1 VDD VDD pmos_lvt l=16n nfin=2
MP_a13_fg14 noh1[14] ifg14_x0 ifg14_a1p VDD pmos_lvt l=16n nfin=2
MP_a14_fg14 noh1[14] ifg14_d1 ifg14_a1p VDD pmos_lvt l=16n nfin=2
MN_a11_fg14 noh1[14] ifg14_d0 ifg14_a1n1 VSS nmos_lvt l=16n nfin=2
MN_a12_fg14 ifg14_a1n1 ifg14_x1 VSS VSS nmos_lvt l=16n nfin=2
MN_a13_fg14 noh1[14] ifg14_x0 ifg14_a1n2 VSS nmos_lvt l=16n nfin=2
MN_a14_fg14 ifg14_a1n2 ifg14_d1 VSS VSS nmos_lvt l=16n nfin=2
MP_n21_fg14 noh2[14] ifg14_d0 VDD VDD pmos_lvt l=16n nfin=2
MP_n22_fg14 noh2[14] ifg14_d1 VDD VDD pmos_lvt l=16n nfin=2
MN_n21_fg14 noh2[14] ifg14_d0 ifg14_n2s VSS nmos_lvt l=16n nfin=2
MN_n22_fg14 ifg14_n2s ifg14_d1 VSS VSS nmos_lvt l=16n nfin=2

* FUSED_G fg15 (40T, ASAP5 extracted: W=0.45u L=0.16u)
MN_ifg15_nai ifg15_nai A[30] VSS VSS nmos_lvt l=16n nfin=2
MP_ifg15_nai ifg15_nai A[30] VDD VDD pmos_lvt l=16n nfin=2
MN_ifg15_nbi ifg15_nbi B[30] VSS VSS nmos_lvt l=16n nfin=2
MP_ifg15_nbi ifg15_nbi B[30] VDD VDD pmos_lvt l=16n nfin=2
MN_ifg15_naj ifg15_naj A[31] VSS VSS nmos_lvt l=16n nfin=2
MP_ifg15_naj ifg15_naj A[31] VDD VDD pmos_lvt l=16n nfin=2
MN_ifg15_nbj ifg15_nbj B[31] VSS VSS nmos_lvt l=16n nfin=2
MP_ifg15_nbj ifg15_nbj B[31] VDD VDD pmos_lvt l=16n nfin=2
MP_q01_fg15 ifg15_x0 ifg15_nai ifg15_q0p1 VDD pmos_lvt l=16n nfin=2
MP_q02_fg15 ifg15_q0p1 ifg15_nbi VDD VDD pmos_lvt l=16n nfin=2
MP_q03_fg15 ifg15_x0 A[30] ifg15_q0p2 VDD pmos_lvt l=16n nfin=2
MP_q04_fg15 ifg15_q0p2 B[30] VDD VDD pmos_lvt l=16n nfin=2
MN_q01_fg15 ifg15_q0n ifg15_nai VSS VSS nmos_lvt l=16n nfin=2
MN_q02_fg15 ifg15_q0n ifg15_nbi VSS VSS nmos_lvt l=16n nfin=2
MN_q03_fg15 ifg15_x0 A[30] ifg15_q0n VSS nmos_lvt l=16n nfin=2
MN_q04_fg15 ifg15_x0 B[30] ifg15_q0n VSS nmos_lvt l=16n nfin=2
MP_q11_fg15 ifg15_x1 ifg15_naj ifg15_q1p1 VDD pmos_lvt l=16n nfin=2
MP_q12_fg15 ifg15_q1p1 ifg15_nbj VDD VDD pmos_lvt l=16n nfin=2
MP_q13_fg15 ifg15_x1 A[31] ifg15_q1p2 VDD pmos_lvt l=16n nfin=2
MP_q14_fg15 ifg15_q1p2 B[31] VDD VDD pmos_lvt l=16n nfin=2
MN_q11_fg15 ifg15_q1n ifg15_naj VSS VSS nmos_lvt l=16n nfin=2
MN_q12_fg15 ifg15_q1n ifg15_nbj VSS VSS nmos_lvt l=16n nfin=2
MN_q13_fg15 ifg15_x1 A[31] ifg15_q1n VSS nmos_lvt l=16n nfin=2
MN_q14_fg15 ifg15_x1 B[31] ifg15_q1n VSS nmos_lvt l=16n nfin=2
MN_ix0_fg15 ifg15_d0 ifg15_x0 VSS VSS nmos_lvt l=16n nfin=2
MP_ix0_fg15 ifg15_d0 ifg15_x0 VDD VDD pmos_lvt l=16n nfin=2
MN_ix1_fg15 ifg15_d1 ifg15_x1 VSS VSS nmos_lvt l=16n nfin=2
MP_ix1_fg15 ifg15_d1 ifg15_x1 VDD VDD pmos_lvt l=16n nfin=2
MP_a11_fg15 ifg15_a1p ifg15_d0 VDD VDD pmos_lvt l=16n nfin=2
MP_a12_fg15 ifg15_a1p ifg15_x1 VDD VDD pmos_lvt l=16n nfin=2
MP_a13_fg15 noh1[15] ifg15_x0 ifg15_a1p VDD pmos_lvt l=16n nfin=2
MP_a14_fg15 noh1[15] ifg15_d1 ifg15_a1p VDD pmos_lvt l=16n nfin=2
MN_a11_fg15 noh1[15] ifg15_d0 ifg15_a1n1 VSS nmos_lvt l=16n nfin=2
MN_a12_fg15 ifg15_a1n1 ifg15_x1 VSS VSS nmos_lvt l=16n nfin=2
MN_a13_fg15 noh1[15] ifg15_x0 ifg15_a1n2 VSS nmos_lvt l=16n nfin=2
MN_a14_fg15 ifg15_a1n2 ifg15_d1 VSS VSS nmos_lvt l=16n nfin=2
MP_n21_fg15 noh2[15] ifg15_d0 VDD VDD pmos_lvt l=16n nfin=2
MP_n22_fg15 noh2[15] ifg15_d1 VDD VDD pmos_lvt l=16n nfin=2
MN_n21_fg15 noh2[15] ifg15_d0 ifg15_n2s VSS nmos_lvt l=16n nfin=2
MN_n22_fg15 ifg15_n2s ifg15_d1 VSS VSS nmos_lvt l=16n nfin=2

* FUSED_G fg16 (40T, ASAP5 extracted: W=0.45u L=0.16u)
MN_ifg16_nai ifg16_nai A[32] VSS VSS nmos_lvt l=16n nfin=2
MP_ifg16_nai ifg16_nai A[32] VDD VDD pmos_lvt l=16n nfin=2
MN_ifg16_nbi ifg16_nbi B[32] VSS VSS nmos_lvt l=16n nfin=2
MP_ifg16_nbi ifg16_nbi B[32] VDD VDD pmos_lvt l=16n nfin=2
MN_ifg16_naj ifg16_naj A[33] VSS VSS nmos_lvt l=16n nfin=2
MP_ifg16_naj ifg16_naj A[33] VDD VDD pmos_lvt l=16n nfin=2
MN_ifg16_nbj ifg16_nbj B[33] VSS VSS nmos_lvt l=16n nfin=2
MP_ifg16_nbj ifg16_nbj B[33] VDD VDD pmos_lvt l=16n nfin=2
MP_q01_fg16 ifg16_x0 ifg16_nai ifg16_q0p1 VDD pmos_lvt l=16n nfin=2
MP_q02_fg16 ifg16_q0p1 ifg16_nbi VDD VDD pmos_lvt l=16n nfin=2
MP_q03_fg16 ifg16_x0 A[32] ifg16_q0p2 VDD pmos_lvt l=16n nfin=2
MP_q04_fg16 ifg16_q0p2 B[32] VDD VDD pmos_lvt l=16n nfin=2
MN_q01_fg16 ifg16_q0n ifg16_nai VSS VSS nmos_lvt l=16n nfin=2
MN_q02_fg16 ifg16_q0n ifg16_nbi VSS VSS nmos_lvt l=16n nfin=2
MN_q03_fg16 ifg16_x0 A[32] ifg16_q0n VSS nmos_lvt l=16n nfin=2
MN_q04_fg16 ifg16_x0 B[32] ifg16_q0n VSS nmos_lvt l=16n nfin=2
MP_q11_fg16 ifg16_x1 ifg16_naj ifg16_q1p1 VDD pmos_lvt l=16n nfin=2
MP_q12_fg16 ifg16_q1p1 ifg16_nbj VDD VDD pmos_lvt l=16n nfin=2
MP_q13_fg16 ifg16_x1 A[33] ifg16_q1p2 VDD pmos_lvt l=16n nfin=2
MP_q14_fg16 ifg16_q1p2 B[33] VDD VDD pmos_lvt l=16n nfin=2
MN_q11_fg16 ifg16_q1n ifg16_naj VSS VSS nmos_lvt l=16n nfin=2
MN_q12_fg16 ifg16_q1n ifg16_nbj VSS VSS nmos_lvt l=16n nfin=2
MN_q13_fg16 ifg16_x1 A[33] ifg16_q1n VSS nmos_lvt l=16n nfin=2
MN_q14_fg16 ifg16_x1 B[33] ifg16_q1n VSS nmos_lvt l=16n nfin=2
MN_ix0_fg16 ifg16_d0 ifg16_x0 VSS VSS nmos_lvt l=16n nfin=2
MP_ix0_fg16 ifg16_d0 ifg16_x0 VDD VDD pmos_lvt l=16n nfin=2
MN_ix1_fg16 ifg16_d1 ifg16_x1 VSS VSS nmos_lvt l=16n nfin=2
MP_ix1_fg16 ifg16_d1 ifg16_x1 VDD VDD pmos_lvt l=16n nfin=2
MP_a11_fg16 ifg16_a1p ifg16_d0 VDD VDD pmos_lvt l=16n nfin=2
MP_a12_fg16 ifg16_a1p ifg16_x1 VDD VDD pmos_lvt l=16n nfin=2
MP_a13_fg16 noh1[16] ifg16_x0 ifg16_a1p VDD pmos_lvt l=16n nfin=2
MP_a14_fg16 noh1[16] ifg16_d1 ifg16_a1p VDD pmos_lvt l=16n nfin=2
MN_a11_fg16 noh1[16] ifg16_d0 ifg16_a1n1 VSS nmos_lvt l=16n nfin=2
MN_a12_fg16 ifg16_a1n1 ifg16_x1 VSS VSS nmos_lvt l=16n nfin=2
MN_a13_fg16 noh1[16] ifg16_x0 ifg16_a1n2 VSS nmos_lvt l=16n nfin=2
MN_a14_fg16 ifg16_a1n2 ifg16_d1 VSS VSS nmos_lvt l=16n nfin=2
MP_n21_fg16 noh2[16] ifg16_d0 VDD VDD pmos_lvt l=16n nfin=2
MP_n22_fg16 noh2[16] ifg16_d1 VDD VDD pmos_lvt l=16n nfin=2
MN_n21_fg16 noh2[16] ifg16_d0 ifg16_n2s VSS nmos_lvt l=16n nfin=2
MN_n22_fg16 ifg16_n2s ifg16_d1 VSS VSS nmos_lvt l=16n nfin=2

* FUSED_G fg17 (40T, ASAP5 extracted: W=0.45u L=0.16u)
MN_ifg17_nai ifg17_nai A[34] VSS VSS nmos_lvt l=16n nfin=2
MP_ifg17_nai ifg17_nai A[34] VDD VDD pmos_lvt l=16n nfin=2
MN_ifg17_nbi ifg17_nbi B[34] VSS VSS nmos_lvt l=16n nfin=2
MP_ifg17_nbi ifg17_nbi B[34] VDD VDD pmos_lvt l=16n nfin=2
MN_ifg17_naj ifg17_naj A[35] VSS VSS nmos_lvt l=16n nfin=2
MP_ifg17_naj ifg17_naj A[35] VDD VDD pmos_lvt l=16n nfin=2
MN_ifg17_nbj ifg17_nbj B[35] VSS VSS nmos_lvt l=16n nfin=2
MP_ifg17_nbj ifg17_nbj B[35] VDD VDD pmos_lvt l=16n nfin=2
MP_q01_fg17 ifg17_x0 ifg17_nai ifg17_q0p1 VDD pmos_lvt l=16n nfin=2
MP_q02_fg17 ifg17_q0p1 ifg17_nbi VDD VDD pmos_lvt l=16n nfin=2
MP_q03_fg17 ifg17_x0 A[34] ifg17_q0p2 VDD pmos_lvt l=16n nfin=2
MP_q04_fg17 ifg17_q0p2 B[34] VDD VDD pmos_lvt l=16n nfin=2
MN_q01_fg17 ifg17_q0n ifg17_nai VSS VSS nmos_lvt l=16n nfin=2
MN_q02_fg17 ifg17_q0n ifg17_nbi VSS VSS nmos_lvt l=16n nfin=2
MN_q03_fg17 ifg17_x0 A[34] ifg17_q0n VSS nmos_lvt l=16n nfin=2
MN_q04_fg17 ifg17_x0 B[34] ifg17_q0n VSS nmos_lvt l=16n nfin=2
MP_q11_fg17 ifg17_x1 ifg17_naj ifg17_q1p1 VDD pmos_lvt l=16n nfin=2
MP_q12_fg17 ifg17_q1p1 ifg17_nbj VDD VDD pmos_lvt l=16n nfin=2
MP_q13_fg17 ifg17_x1 A[35] ifg17_q1p2 VDD pmos_lvt l=16n nfin=2
MP_q14_fg17 ifg17_q1p2 B[35] VDD VDD pmos_lvt l=16n nfin=2
MN_q11_fg17 ifg17_q1n ifg17_naj VSS VSS nmos_lvt l=16n nfin=2
MN_q12_fg17 ifg17_q1n ifg17_nbj VSS VSS nmos_lvt l=16n nfin=2
MN_q13_fg17 ifg17_x1 A[35] ifg17_q1n VSS nmos_lvt l=16n nfin=2
MN_q14_fg17 ifg17_x1 B[35] ifg17_q1n VSS nmos_lvt l=16n nfin=2
MN_ix0_fg17 ifg17_d0 ifg17_x0 VSS VSS nmos_lvt l=16n nfin=2
MP_ix0_fg17 ifg17_d0 ifg17_x0 VDD VDD pmos_lvt l=16n nfin=2
MN_ix1_fg17 ifg17_d1 ifg17_x1 VSS VSS nmos_lvt l=16n nfin=2
MP_ix1_fg17 ifg17_d1 ifg17_x1 VDD VDD pmos_lvt l=16n nfin=2
MP_a11_fg17 ifg17_a1p ifg17_d0 VDD VDD pmos_lvt l=16n nfin=2
MP_a12_fg17 ifg17_a1p ifg17_x1 VDD VDD pmos_lvt l=16n nfin=2
MP_a13_fg17 noh1[17] ifg17_x0 ifg17_a1p VDD pmos_lvt l=16n nfin=2
MP_a14_fg17 noh1[17] ifg17_d1 ifg17_a1p VDD pmos_lvt l=16n nfin=2
MN_a11_fg17 noh1[17] ifg17_d0 ifg17_a1n1 VSS nmos_lvt l=16n nfin=2
MN_a12_fg17 ifg17_a1n1 ifg17_x1 VSS VSS nmos_lvt l=16n nfin=2
MN_a13_fg17 noh1[17] ifg17_x0 ifg17_a1n2 VSS nmos_lvt l=16n nfin=2
MN_a14_fg17 ifg17_a1n2 ifg17_d1 VSS VSS nmos_lvt l=16n nfin=2
MP_n21_fg17 noh2[17] ifg17_d0 VDD VDD pmos_lvt l=16n nfin=2
MP_n22_fg17 noh2[17] ifg17_d1 VDD VDD pmos_lvt l=16n nfin=2
MN_n21_fg17 noh2[17] ifg17_d0 ifg17_n2s VSS nmos_lvt l=16n nfin=2
MN_n22_fg17 ifg17_n2s ifg17_d1 VSS VSS nmos_lvt l=16n nfin=2

* FUSED_G fg18 (40T, ASAP5 extracted: W=0.45u L=0.16u)
MN_ifg18_nai ifg18_nai A[36] VSS VSS nmos_lvt l=16n nfin=2
MP_ifg18_nai ifg18_nai A[36] VDD VDD pmos_lvt l=16n nfin=2
MN_ifg18_nbi ifg18_nbi B[36] VSS VSS nmos_lvt l=16n nfin=2
MP_ifg18_nbi ifg18_nbi B[36] VDD VDD pmos_lvt l=16n nfin=2
MN_ifg18_naj ifg18_naj A[37] VSS VSS nmos_lvt l=16n nfin=2
MP_ifg18_naj ifg18_naj A[37] VDD VDD pmos_lvt l=16n nfin=2
MN_ifg18_nbj ifg18_nbj B[37] VSS VSS nmos_lvt l=16n nfin=2
MP_ifg18_nbj ifg18_nbj B[37] VDD VDD pmos_lvt l=16n nfin=2
MP_q01_fg18 ifg18_x0 ifg18_nai ifg18_q0p1 VDD pmos_lvt l=16n nfin=2
MP_q02_fg18 ifg18_q0p1 ifg18_nbi VDD VDD pmos_lvt l=16n nfin=2
MP_q03_fg18 ifg18_x0 A[36] ifg18_q0p2 VDD pmos_lvt l=16n nfin=2
MP_q04_fg18 ifg18_q0p2 B[36] VDD VDD pmos_lvt l=16n nfin=2
MN_q01_fg18 ifg18_q0n ifg18_nai VSS VSS nmos_lvt l=16n nfin=2
MN_q02_fg18 ifg18_q0n ifg18_nbi VSS VSS nmos_lvt l=16n nfin=2
MN_q03_fg18 ifg18_x0 A[36] ifg18_q0n VSS nmos_lvt l=16n nfin=2
MN_q04_fg18 ifg18_x0 B[36] ifg18_q0n VSS nmos_lvt l=16n nfin=2
MP_q11_fg18 ifg18_x1 ifg18_naj ifg18_q1p1 VDD pmos_lvt l=16n nfin=2
MP_q12_fg18 ifg18_q1p1 ifg18_nbj VDD VDD pmos_lvt l=16n nfin=2
MP_q13_fg18 ifg18_x1 A[37] ifg18_q1p2 VDD pmos_lvt l=16n nfin=2
MP_q14_fg18 ifg18_q1p2 B[37] VDD VDD pmos_lvt l=16n nfin=2
MN_q11_fg18 ifg18_q1n ifg18_naj VSS VSS nmos_lvt l=16n nfin=2
MN_q12_fg18 ifg18_q1n ifg18_nbj VSS VSS nmos_lvt l=16n nfin=2
MN_q13_fg18 ifg18_x1 A[37] ifg18_q1n VSS nmos_lvt l=16n nfin=2
MN_q14_fg18 ifg18_x1 B[37] ifg18_q1n VSS nmos_lvt l=16n nfin=2
MN_ix0_fg18 ifg18_d0 ifg18_x0 VSS VSS nmos_lvt l=16n nfin=2
MP_ix0_fg18 ifg18_d0 ifg18_x0 VDD VDD pmos_lvt l=16n nfin=2
MN_ix1_fg18 ifg18_d1 ifg18_x1 VSS VSS nmos_lvt l=16n nfin=2
MP_ix1_fg18 ifg18_d1 ifg18_x1 VDD VDD pmos_lvt l=16n nfin=2
MP_a11_fg18 ifg18_a1p ifg18_d0 VDD VDD pmos_lvt l=16n nfin=2
MP_a12_fg18 ifg18_a1p ifg18_x1 VDD VDD pmos_lvt l=16n nfin=2
MP_a13_fg18 noh1[18] ifg18_x0 ifg18_a1p VDD pmos_lvt l=16n nfin=2
MP_a14_fg18 noh1[18] ifg18_d1 ifg18_a1p VDD pmos_lvt l=16n nfin=2
MN_a11_fg18 noh1[18] ifg18_d0 ifg18_a1n1 VSS nmos_lvt l=16n nfin=2
MN_a12_fg18 ifg18_a1n1 ifg18_x1 VSS VSS nmos_lvt l=16n nfin=2
MN_a13_fg18 noh1[18] ifg18_x0 ifg18_a1n2 VSS nmos_lvt l=16n nfin=2
MN_a14_fg18 ifg18_a1n2 ifg18_d1 VSS VSS nmos_lvt l=16n nfin=2
MP_n21_fg18 noh2[18] ifg18_d0 VDD VDD pmos_lvt l=16n nfin=2
MP_n22_fg18 noh2[18] ifg18_d1 VDD VDD pmos_lvt l=16n nfin=2
MN_n21_fg18 noh2[18] ifg18_d0 ifg18_n2s VSS nmos_lvt l=16n nfin=2
MN_n22_fg18 ifg18_n2s ifg18_d1 VSS VSS nmos_lvt l=16n nfin=2

* FUSED_G fg19 (40T, ASAP5 extracted: W=0.45u L=0.16u)
MN_ifg19_nai ifg19_nai A[38] VSS VSS nmos_lvt l=16n nfin=2
MP_ifg19_nai ifg19_nai A[38] VDD VDD pmos_lvt l=16n nfin=2
MN_ifg19_nbi ifg19_nbi B[38] VSS VSS nmos_lvt l=16n nfin=2
MP_ifg19_nbi ifg19_nbi B[38] VDD VDD pmos_lvt l=16n nfin=2
MN_ifg19_naj ifg19_naj A[39] VSS VSS nmos_lvt l=16n nfin=2
MP_ifg19_naj ifg19_naj A[39] VDD VDD pmos_lvt l=16n nfin=2
MN_ifg19_nbj ifg19_nbj B[39] VSS VSS nmos_lvt l=16n nfin=2
MP_ifg19_nbj ifg19_nbj B[39] VDD VDD pmos_lvt l=16n nfin=2
MP_q01_fg19 ifg19_x0 ifg19_nai ifg19_q0p1 VDD pmos_lvt l=16n nfin=2
MP_q02_fg19 ifg19_q0p1 ifg19_nbi VDD VDD pmos_lvt l=16n nfin=2
MP_q03_fg19 ifg19_x0 A[38] ifg19_q0p2 VDD pmos_lvt l=16n nfin=2
MP_q04_fg19 ifg19_q0p2 B[38] VDD VDD pmos_lvt l=16n nfin=2
MN_q01_fg19 ifg19_q0n ifg19_nai VSS VSS nmos_lvt l=16n nfin=2
MN_q02_fg19 ifg19_q0n ifg19_nbi VSS VSS nmos_lvt l=16n nfin=2
MN_q03_fg19 ifg19_x0 A[38] ifg19_q0n VSS nmos_lvt l=16n nfin=2
MN_q04_fg19 ifg19_x0 B[38] ifg19_q0n VSS nmos_lvt l=16n nfin=2
MP_q11_fg19 ifg19_x1 ifg19_naj ifg19_q1p1 VDD pmos_lvt l=16n nfin=2
MP_q12_fg19 ifg19_q1p1 ifg19_nbj VDD VDD pmos_lvt l=16n nfin=2
MP_q13_fg19 ifg19_x1 A[39] ifg19_q1p2 VDD pmos_lvt l=16n nfin=2
MP_q14_fg19 ifg19_q1p2 B[39] VDD VDD pmos_lvt l=16n nfin=2
MN_q11_fg19 ifg19_q1n ifg19_naj VSS VSS nmos_lvt l=16n nfin=2
MN_q12_fg19 ifg19_q1n ifg19_nbj VSS VSS nmos_lvt l=16n nfin=2
MN_q13_fg19 ifg19_x1 A[39] ifg19_q1n VSS nmos_lvt l=16n nfin=2
MN_q14_fg19 ifg19_x1 B[39] ifg19_q1n VSS nmos_lvt l=16n nfin=2
MN_ix0_fg19 ifg19_d0 ifg19_x0 VSS VSS nmos_lvt l=16n nfin=2
MP_ix0_fg19 ifg19_d0 ifg19_x0 VDD VDD pmos_lvt l=16n nfin=2
MN_ix1_fg19 ifg19_d1 ifg19_x1 VSS VSS nmos_lvt l=16n nfin=2
MP_ix1_fg19 ifg19_d1 ifg19_x1 VDD VDD pmos_lvt l=16n nfin=2
MP_a11_fg19 ifg19_a1p ifg19_d0 VDD VDD pmos_lvt l=16n nfin=2
MP_a12_fg19 ifg19_a1p ifg19_x1 VDD VDD pmos_lvt l=16n nfin=2
MP_a13_fg19 noh1[19] ifg19_x0 ifg19_a1p VDD pmos_lvt l=16n nfin=2
MP_a14_fg19 noh1[19] ifg19_d1 ifg19_a1p VDD pmos_lvt l=16n nfin=2
MN_a11_fg19 noh1[19] ifg19_d0 ifg19_a1n1 VSS nmos_lvt l=16n nfin=2
MN_a12_fg19 ifg19_a1n1 ifg19_x1 VSS VSS nmos_lvt l=16n nfin=2
MN_a13_fg19 noh1[19] ifg19_x0 ifg19_a1n2 VSS nmos_lvt l=16n nfin=2
MN_a14_fg19 ifg19_a1n2 ifg19_d1 VSS VSS nmos_lvt l=16n nfin=2
MP_n21_fg19 noh2[19] ifg19_d0 VDD VDD pmos_lvt l=16n nfin=2
MP_n22_fg19 noh2[19] ifg19_d1 VDD VDD pmos_lvt l=16n nfin=2
MN_n21_fg19 noh2[19] ifg19_d0 ifg19_n2s VSS nmos_lvt l=16n nfin=2
MN_n22_fg19 ifg19_n2s ifg19_d1 VSS VSS nmos_lvt l=16n nfin=2

* FUSED_G fg20 (40T, ASAP5 extracted: W=0.45u L=0.16u)
MN_ifg20_nai ifg20_nai A[40] VSS VSS nmos_lvt l=16n nfin=2
MP_ifg20_nai ifg20_nai A[40] VDD VDD pmos_lvt l=16n nfin=2
MN_ifg20_nbi ifg20_nbi B[40] VSS VSS nmos_lvt l=16n nfin=2
MP_ifg20_nbi ifg20_nbi B[40] VDD VDD pmos_lvt l=16n nfin=2
MN_ifg20_naj ifg20_naj A[41] VSS VSS nmos_lvt l=16n nfin=2
MP_ifg20_naj ifg20_naj A[41] VDD VDD pmos_lvt l=16n nfin=2
MN_ifg20_nbj ifg20_nbj B[41] VSS VSS nmos_lvt l=16n nfin=2
MP_ifg20_nbj ifg20_nbj B[41] VDD VDD pmos_lvt l=16n nfin=2
MP_q01_fg20 ifg20_x0 ifg20_nai ifg20_q0p1 VDD pmos_lvt l=16n nfin=2
MP_q02_fg20 ifg20_q0p1 ifg20_nbi VDD VDD pmos_lvt l=16n nfin=2
MP_q03_fg20 ifg20_x0 A[40] ifg20_q0p2 VDD pmos_lvt l=16n nfin=2
MP_q04_fg20 ifg20_q0p2 B[40] VDD VDD pmos_lvt l=16n nfin=2
MN_q01_fg20 ifg20_q0n ifg20_nai VSS VSS nmos_lvt l=16n nfin=2
MN_q02_fg20 ifg20_q0n ifg20_nbi VSS VSS nmos_lvt l=16n nfin=2
MN_q03_fg20 ifg20_x0 A[40] ifg20_q0n VSS nmos_lvt l=16n nfin=2
MN_q04_fg20 ifg20_x0 B[40] ifg20_q0n VSS nmos_lvt l=16n nfin=2
MP_q11_fg20 ifg20_x1 ifg20_naj ifg20_q1p1 VDD pmos_lvt l=16n nfin=2
MP_q12_fg20 ifg20_q1p1 ifg20_nbj VDD VDD pmos_lvt l=16n nfin=2
MP_q13_fg20 ifg20_x1 A[41] ifg20_q1p2 VDD pmos_lvt l=16n nfin=2
MP_q14_fg20 ifg20_q1p2 B[41] VDD VDD pmos_lvt l=16n nfin=2
MN_q11_fg20 ifg20_q1n ifg20_naj VSS VSS nmos_lvt l=16n nfin=2
MN_q12_fg20 ifg20_q1n ifg20_nbj VSS VSS nmos_lvt l=16n nfin=2
MN_q13_fg20 ifg20_x1 A[41] ifg20_q1n VSS nmos_lvt l=16n nfin=2
MN_q14_fg20 ifg20_x1 B[41] ifg20_q1n VSS nmos_lvt l=16n nfin=2
MN_ix0_fg20 ifg20_d0 ifg20_x0 VSS VSS nmos_lvt l=16n nfin=2
MP_ix0_fg20 ifg20_d0 ifg20_x0 VDD VDD pmos_lvt l=16n nfin=2
MN_ix1_fg20 ifg20_d1 ifg20_x1 VSS VSS nmos_lvt l=16n nfin=2
MP_ix1_fg20 ifg20_d1 ifg20_x1 VDD VDD pmos_lvt l=16n nfin=2
MP_a11_fg20 ifg20_a1p ifg20_d0 VDD VDD pmos_lvt l=16n nfin=2
MP_a12_fg20 ifg20_a1p ifg20_x1 VDD VDD pmos_lvt l=16n nfin=2
MP_a13_fg20 noh1[20] ifg20_x0 ifg20_a1p VDD pmos_lvt l=16n nfin=2
MP_a14_fg20 noh1[20] ifg20_d1 ifg20_a1p VDD pmos_lvt l=16n nfin=2
MN_a11_fg20 noh1[20] ifg20_d0 ifg20_a1n1 VSS nmos_lvt l=16n nfin=2
MN_a12_fg20 ifg20_a1n1 ifg20_x1 VSS VSS nmos_lvt l=16n nfin=2
MN_a13_fg20 noh1[20] ifg20_x0 ifg20_a1n2 VSS nmos_lvt l=16n nfin=2
MN_a14_fg20 ifg20_a1n2 ifg20_d1 VSS VSS nmos_lvt l=16n nfin=2
MP_n21_fg20 noh2[20] ifg20_d0 VDD VDD pmos_lvt l=16n nfin=2
MP_n22_fg20 noh2[20] ifg20_d1 VDD VDD pmos_lvt l=16n nfin=2
MN_n21_fg20 noh2[20] ifg20_d0 ifg20_n2s VSS nmos_lvt l=16n nfin=2
MN_n22_fg20 ifg20_n2s ifg20_d1 VSS VSS nmos_lvt l=16n nfin=2

* FUSED_G fg21 (40T, ASAP5 extracted: W=0.45u L=0.16u)
MN_ifg21_nai ifg21_nai A[42] VSS VSS nmos_lvt l=16n nfin=2
MP_ifg21_nai ifg21_nai A[42] VDD VDD pmos_lvt l=16n nfin=2
MN_ifg21_nbi ifg21_nbi B[42] VSS VSS nmos_lvt l=16n nfin=2
MP_ifg21_nbi ifg21_nbi B[42] VDD VDD pmos_lvt l=16n nfin=2
MN_ifg21_naj ifg21_naj A[43] VSS VSS nmos_lvt l=16n nfin=2
MP_ifg21_naj ifg21_naj A[43] VDD VDD pmos_lvt l=16n nfin=2
MN_ifg21_nbj ifg21_nbj B[43] VSS VSS nmos_lvt l=16n nfin=2
MP_ifg21_nbj ifg21_nbj B[43] VDD VDD pmos_lvt l=16n nfin=2
MP_q01_fg21 ifg21_x0 ifg21_nai ifg21_q0p1 VDD pmos_lvt l=16n nfin=2
MP_q02_fg21 ifg21_q0p1 ifg21_nbi VDD VDD pmos_lvt l=16n nfin=2
MP_q03_fg21 ifg21_x0 A[42] ifg21_q0p2 VDD pmos_lvt l=16n nfin=2
MP_q04_fg21 ifg21_q0p2 B[42] VDD VDD pmos_lvt l=16n nfin=2
MN_q01_fg21 ifg21_q0n ifg21_nai VSS VSS nmos_lvt l=16n nfin=2
MN_q02_fg21 ifg21_q0n ifg21_nbi VSS VSS nmos_lvt l=16n nfin=2
MN_q03_fg21 ifg21_x0 A[42] ifg21_q0n VSS nmos_lvt l=16n nfin=2
MN_q04_fg21 ifg21_x0 B[42] ifg21_q0n VSS nmos_lvt l=16n nfin=2
MP_q11_fg21 ifg21_x1 ifg21_naj ifg21_q1p1 VDD pmos_lvt l=16n nfin=2
MP_q12_fg21 ifg21_q1p1 ifg21_nbj VDD VDD pmos_lvt l=16n nfin=2
MP_q13_fg21 ifg21_x1 A[43] ifg21_q1p2 VDD pmos_lvt l=16n nfin=2
MP_q14_fg21 ifg21_q1p2 B[43] VDD VDD pmos_lvt l=16n nfin=2
MN_q11_fg21 ifg21_q1n ifg21_naj VSS VSS nmos_lvt l=16n nfin=2
MN_q12_fg21 ifg21_q1n ifg21_nbj VSS VSS nmos_lvt l=16n nfin=2
MN_q13_fg21 ifg21_x1 A[43] ifg21_q1n VSS nmos_lvt l=16n nfin=2
MN_q14_fg21 ifg21_x1 B[43] ifg21_q1n VSS nmos_lvt l=16n nfin=2
MN_ix0_fg21 ifg21_d0 ifg21_x0 VSS VSS nmos_lvt l=16n nfin=2
MP_ix0_fg21 ifg21_d0 ifg21_x0 VDD VDD pmos_lvt l=16n nfin=2
MN_ix1_fg21 ifg21_d1 ifg21_x1 VSS VSS nmos_lvt l=16n nfin=2
MP_ix1_fg21 ifg21_d1 ifg21_x1 VDD VDD pmos_lvt l=16n nfin=2
MP_a11_fg21 ifg21_a1p ifg21_d0 VDD VDD pmos_lvt l=16n nfin=2
MP_a12_fg21 ifg21_a1p ifg21_x1 VDD VDD pmos_lvt l=16n nfin=2
MP_a13_fg21 noh1[21] ifg21_x0 ifg21_a1p VDD pmos_lvt l=16n nfin=2
MP_a14_fg21 noh1[21] ifg21_d1 ifg21_a1p VDD pmos_lvt l=16n nfin=2
MN_a11_fg21 noh1[21] ifg21_d0 ifg21_a1n1 VSS nmos_lvt l=16n nfin=2
MN_a12_fg21 ifg21_a1n1 ifg21_x1 VSS VSS nmos_lvt l=16n nfin=2
MN_a13_fg21 noh1[21] ifg21_x0 ifg21_a1n2 VSS nmos_lvt l=16n nfin=2
MN_a14_fg21 ifg21_a1n2 ifg21_d1 VSS VSS nmos_lvt l=16n nfin=2
MP_n21_fg21 noh2[21] ifg21_d0 VDD VDD pmos_lvt l=16n nfin=2
MP_n22_fg21 noh2[21] ifg21_d1 VDD VDD pmos_lvt l=16n nfin=2
MN_n21_fg21 noh2[21] ifg21_d0 ifg21_n2s VSS nmos_lvt l=16n nfin=2
MN_n22_fg21 ifg21_n2s ifg21_d1 VSS VSS nmos_lvt l=16n nfin=2

* FUSED_G fg22 (40T, ASAP5 extracted: W=0.45u L=0.16u)
MN_ifg22_nai ifg22_nai A[44] VSS VSS nmos_lvt l=16n nfin=2
MP_ifg22_nai ifg22_nai A[44] VDD VDD pmos_lvt l=16n nfin=2
MN_ifg22_nbi ifg22_nbi B[44] VSS VSS nmos_lvt l=16n nfin=2
MP_ifg22_nbi ifg22_nbi B[44] VDD VDD pmos_lvt l=16n nfin=2
MN_ifg22_naj ifg22_naj A[45] VSS VSS nmos_lvt l=16n nfin=2
MP_ifg22_naj ifg22_naj A[45] VDD VDD pmos_lvt l=16n nfin=2
MN_ifg22_nbj ifg22_nbj B[45] VSS VSS nmos_lvt l=16n nfin=2
MP_ifg22_nbj ifg22_nbj B[45] VDD VDD pmos_lvt l=16n nfin=2
MP_q01_fg22 ifg22_x0 ifg22_nai ifg22_q0p1 VDD pmos_lvt l=16n nfin=2
MP_q02_fg22 ifg22_q0p1 ifg22_nbi VDD VDD pmos_lvt l=16n nfin=2
MP_q03_fg22 ifg22_x0 A[44] ifg22_q0p2 VDD pmos_lvt l=16n nfin=2
MP_q04_fg22 ifg22_q0p2 B[44] VDD VDD pmos_lvt l=16n nfin=2
MN_q01_fg22 ifg22_q0n ifg22_nai VSS VSS nmos_lvt l=16n nfin=2
MN_q02_fg22 ifg22_q0n ifg22_nbi VSS VSS nmos_lvt l=16n nfin=2
MN_q03_fg22 ifg22_x0 A[44] ifg22_q0n VSS nmos_lvt l=16n nfin=2
MN_q04_fg22 ifg22_x0 B[44] ifg22_q0n VSS nmos_lvt l=16n nfin=2
MP_q11_fg22 ifg22_x1 ifg22_naj ifg22_q1p1 VDD pmos_lvt l=16n nfin=2
MP_q12_fg22 ifg22_q1p1 ifg22_nbj VDD VDD pmos_lvt l=16n nfin=2
MP_q13_fg22 ifg22_x1 A[45] ifg22_q1p2 VDD pmos_lvt l=16n nfin=2
MP_q14_fg22 ifg22_q1p2 B[45] VDD VDD pmos_lvt l=16n nfin=2
MN_q11_fg22 ifg22_q1n ifg22_naj VSS VSS nmos_lvt l=16n nfin=2
MN_q12_fg22 ifg22_q1n ifg22_nbj VSS VSS nmos_lvt l=16n nfin=2
MN_q13_fg22 ifg22_x1 A[45] ifg22_q1n VSS nmos_lvt l=16n nfin=2
MN_q14_fg22 ifg22_x1 B[45] ifg22_q1n VSS nmos_lvt l=16n nfin=2
MN_ix0_fg22 ifg22_d0 ifg22_x0 VSS VSS nmos_lvt l=16n nfin=2
MP_ix0_fg22 ifg22_d0 ifg22_x0 VDD VDD pmos_lvt l=16n nfin=2
MN_ix1_fg22 ifg22_d1 ifg22_x1 VSS VSS nmos_lvt l=16n nfin=2
MP_ix1_fg22 ifg22_d1 ifg22_x1 VDD VDD pmos_lvt l=16n nfin=2
MP_a11_fg22 ifg22_a1p ifg22_d0 VDD VDD pmos_lvt l=16n nfin=2
MP_a12_fg22 ifg22_a1p ifg22_x1 VDD VDD pmos_lvt l=16n nfin=2
MP_a13_fg22 noh1[22] ifg22_x0 ifg22_a1p VDD pmos_lvt l=16n nfin=2
MP_a14_fg22 noh1[22] ifg22_d1 ifg22_a1p VDD pmos_lvt l=16n nfin=2
MN_a11_fg22 noh1[22] ifg22_d0 ifg22_a1n1 VSS nmos_lvt l=16n nfin=2
MN_a12_fg22 ifg22_a1n1 ifg22_x1 VSS VSS nmos_lvt l=16n nfin=2
MN_a13_fg22 noh1[22] ifg22_x0 ifg22_a1n2 VSS nmos_lvt l=16n nfin=2
MN_a14_fg22 ifg22_a1n2 ifg22_d1 VSS VSS nmos_lvt l=16n nfin=2
MP_n21_fg22 noh2[22] ifg22_d0 VDD VDD pmos_lvt l=16n nfin=2
MP_n22_fg22 noh2[22] ifg22_d1 VDD VDD pmos_lvt l=16n nfin=2
MN_n21_fg22 noh2[22] ifg22_d0 ifg22_n2s VSS nmos_lvt l=16n nfin=2
MN_n22_fg22 ifg22_n2s ifg22_d1 VSS VSS nmos_lvt l=16n nfin=2

* FUSED_G fg23 (40T, ASAP5 extracted: W=0.45u L=0.16u)
MN_ifg23_nai ifg23_nai A[46] VSS VSS nmos_lvt l=16n nfin=2
MP_ifg23_nai ifg23_nai A[46] VDD VDD pmos_lvt l=16n nfin=2
MN_ifg23_nbi ifg23_nbi B[46] VSS VSS nmos_lvt l=16n nfin=2
MP_ifg23_nbi ifg23_nbi B[46] VDD VDD pmos_lvt l=16n nfin=2
MN_ifg23_naj ifg23_naj A[47] VSS VSS nmos_lvt l=16n nfin=2
MP_ifg23_naj ifg23_naj A[47] VDD VDD pmos_lvt l=16n nfin=2
MN_ifg23_nbj ifg23_nbj B[47] VSS VSS nmos_lvt l=16n nfin=2
MP_ifg23_nbj ifg23_nbj B[47] VDD VDD pmos_lvt l=16n nfin=2
MP_q01_fg23 ifg23_x0 ifg23_nai ifg23_q0p1 VDD pmos_lvt l=16n nfin=2
MP_q02_fg23 ifg23_q0p1 ifg23_nbi VDD VDD pmos_lvt l=16n nfin=2
MP_q03_fg23 ifg23_x0 A[46] ifg23_q0p2 VDD pmos_lvt l=16n nfin=2
MP_q04_fg23 ifg23_q0p2 B[46] VDD VDD pmos_lvt l=16n nfin=2
MN_q01_fg23 ifg23_q0n ifg23_nai VSS VSS nmos_lvt l=16n nfin=2
MN_q02_fg23 ifg23_q0n ifg23_nbi VSS VSS nmos_lvt l=16n nfin=2
MN_q03_fg23 ifg23_x0 A[46] ifg23_q0n VSS nmos_lvt l=16n nfin=2
MN_q04_fg23 ifg23_x0 B[46] ifg23_q0n VSS nmos_lvt l=16n nfin=2
MP_q11_fg23 ifg23_x1 ifg23_naj ifg23_q1p1 VDD pmos_lvt l=16n nfin=2
MP_q12_fg23 ifg23_q1p1 ifg23_nbj VDD VDD pmos_lvt l=16n nfin=2
MP_q13_fg23 ifg23_x1 A[47] ifg23_q1p2 VDD pmos_lvt l=16n nfin=2
MP_q14_fg23 ifg23_q1p2 B[47] VDD VDD pmos_lvt l=16n nfin=2
MN_q11_fg23 ifg23_q1n ifg23_naj VSS VSS nmos_lvt l=16n nfin=2
MN_q12_fg23 ifg23_q1n ifg23_nbj VSS VSS nmos_lvt l=16n nfin=2
MN_q13_fg23 ifg23_x1 A[47] ifg23_q1n VSS nmos_lvt l=16n nfin=2
MN_q14_fg23 ifg23_x1 B[47] ifg23_q1n VSS nmos_lvt l=16n nfin=2
MN_ix0_fg23 ifg23_d0 ifg23_x0 VSS VSS nmos_lvt l=16n nfin=2
MP_ix0_fg23 ifg23_d0 ifg23_x0 VDD VDD pmos_lvt l=16n nfin=2
MN_ix1_fg23 ifg23_d1 ifg23_x1 VSS VSS nmos_lvt l=16n nfin=2
MP_ix1_fg23 ifg23_d1 ifg23_x1 VDD VDD pmos_lvt l=16n nfin=2
MP_a11_fg23 ifg23_a1p ifg23_d0 VDD VDD pmos_lvt l=16n nfin=2
MP_a12_fg23 ifg23_a1p ifg23_x1 VDD VDD pmos_lvt l=16n nfin=2
MP_a13_fg23 noh1[23] ifg23_x0 ifg23_a1p VDD pmos_lvt l=16n nfin=2
MP_a14_fg23 noh1[23] ifg23_d1 ifg23_a1p VDD pmos_lvt l=16n nfin=2
MN_a11_fg23 noh1[23] ifg23_d0 ifg23_a1n1 VSS nmos_lvt l=16n nfin=2
MN_a12_fg23 ifg23_a1n1 ifg23_x1 VSS VSS nmos_lvt l=16n nfin=2
MN_a13_fg23 noh1[23] ifg23_x0 ifg23_a1n2 VSS nmos_lvt l=16n nfin=2
MN_a14_fg23 ifg23_a1n2 ifg23_d1 VSS VSS nmos_lvt l=16n nfin=2
MP_n21_fg23 noh2[23] ifg23_d0 VDD VDD pmos_lvt l=16n nfin=2
MP_n22_fg23 noh2[23] ifg23_d1 VDD VDD pmos_lvt l=16n nfin=2
MN_n21_fg23 noh2[23] ifg23_d0 ifg23_n2s VSS nmos_lvt l=16n nfin=2
MN_n22_fg23 ifg23_n2s ifg23_d1 VSS VSS nmos_lvt l=16n nfin=2

* FUSED_G fg24 (40T, ASAP5 extracted: W=0.45u L=0.16u)
MN_ifg24_nai ifg24_nai A[48] VSS VSS nmos_lvt l=16n nfin=2
MP_ifg24_nai ifg24_nai A[48] VDD VDD pmos_lvt l=16n nfin=2
MN_ifg24_nbi ifg24_nbi B[48] VSS VSS nmos_lvt l=16n nfin=2
MP_ifg24_nbi ifg24_nbi B[48] VDD VDD pmos_lvt l=16n nfin=2
MN_ifg24_naj ifg24_naj A[49] VSS VSS nmos_lvt l=16n nfin=2
MP_ifg24_naj ifg24_naj A[49] VDD VDD pmos_lvt l=16n nfin=2
MN_ifg24_nbj ifg24_nbj B[49] VSS VSS nmos_lvt l=16n nfin=2
MP_ifg24_nbj ifg24_nbj B[49] VDD VDD pmos_lvt l=16n nfin=2
MP_q01_fg24 ifg24_x0 ifg24_nai ifg24_q0p1 VDD pmos_lvt l=16n nfin=2
MP_q02_fg24 ifg24_q0p1 ifg24_nbi VDD VDD pmos_lvt l=16n nfin=2
MP_q03_fg24 ifg24_x0 A[48] ifg24_q0p2 VDD pmos_lvt l=16n nfin=2
MP_q04_fg24 ifg24_q0p2 B[48] VDD VDD pmos_lvt l=16n nfin=2
MN_q01_fg24 ifg24_q0n ifg24_nai VSS VSS nmos_lvt l=16n nfin=2
MN_q02_fg24 ifg24_q0n ifg24_nbi VSS VSS nmos_lvt l=16n nfin=2
MN_q03_fg24 ifg24_x0 A[48] ifg24_q0n VSS nmos_lvt l=16n nfin=2
MN_q04_fg24 ifg24_x0 B[48] ifg24_q0n VSS nmos_lvt l=16n nfin=2
MP_q11_fg24 ifg24_x1 ifg24_naj ifg24_q1p1 VDD pmos_lvt l=16n nfin=2
MP_q12_fg24 ifg24_q1p1 ifg24_nbj VDD VDD pmos_lvt l=16n nfin=2
MP_q13_fg24 ifg24_x1 A[49] ifg24_q1p2 VDD pmos_lvt l=16n nfin=2
MP_q14_fg24 ifg24_q1p2 B[49] VDD VDD pmos_lvt l=16n nfin=2
MN_q11_fg24 ifg24_q1n ifg24_naj VSS VSS nmos_lvt l=16n nfin=2
MN_q12_fg24 ifg24_q1n ifg24_nbj VSS VSS nmos_lvt l=16n nfin=2
MN_q13_fg24 ifg24_x1 A[49] ifg24_q1n VSS nmos_lvt l=16n nfin=2
MN_q14_fg24 ifg24_x1 B[49] ifg24_q1n VSS nmos_lvt l=16n nfin=2
MN_ix0_fg24 ifg24_d0 ifg24_x0 VSS VSS nmos_lvt l=16n nfin=2
MP_ix0_fg24 ifg24_d0 ifg24_x0 VDD VDD pmos_lvt l=16n nfin=2
MN_ix1_fg24 ifg24_d1 ifg24_x1 VSS VSS nmos_lvt l=16n nfin=2
MP_ix1_fg24 ifg24_d1 ifg24_x1 VDD VDD pmos_lvt l=16n nfin=2
MP_a11_fg24 ifg24_a1p ifg24_d0 VDD VDD pmos_lvt l=16n nfin=2
MP_a12_fg24 ifg24_a1p ifg24_x1 VDD VDD pmos_lvt l=16n nfin=2
MP_a13_fg24 noh1[24] ifg24_x0 ifg24_a1p VDD pmos_lvt l=16n nfin=2
MP_a14_fg24 noh1[24] ifg24_d1 ifg24_a1p VDD pmos_lvt l=16n nfin=2
MN_a11_fg24 noh1[24] ifg24_d0 ifg24_a1n1 VSS nmos_lvt l=16n nfin=2
MN_a12_fg24 ifg24_a1n1 ifg24_x1 VSS VSS nmos_lvt l=16n nfin=2
MN_a13_fg24 noh1[24] ifg24_x0 ifg24_a1n2 VSS nmos_lvt l=16n nfin=2
MN_a14_fg24 ifg24_a1n2 ifg24_d1 VSS VSS nmos_lvt l=16n nfin=2
MP_n21_fg24 noh2[24] ifg24_d0 VDD VDD pmos_lvt l=16n nfin=2
MP_n22_fg24 noh2[24] ifg24_d1 VDD VDD pmos_lvt l=16n nfin=2
MN_n21_fg24 noh2[24] ifg24_d0 ifg24_n2s VSS nmos_lvt l=16n nfin=2
MN_n22_fg24 ifg24_n2s ifg24_d1 VSS VSS nmos_lvt l=16n nfin=2

* FUSED_G fg25 (40T, ASAP5 extracted: W=0.45u L=0.16u)
MN_ifg25_nai ifg25_nai A[50] VSS VSS nmos_lvt l=16n nfin=2
MP_ifg25_nai ifg25_nai A[50] VDD VDD pmos_lvt l=16n nfin=2
MN_ifg25_nbi ifg25_nbi B[50] VSS VSS nmos_lvt l=16n nfin=2
MP_ifg25_nbi ifg25_nbi B[50] VDD VDD pmos_lvt l=16n nfin=2
MN_ifg25_naj ifg25_naj A[51] VSS VSS nmos_lvt l=16n nfin=2
MP_ifg25_naj ifg25_naj A[51] VDD VDD pmos_lvt l=16n nfin=2
MN_ifg25_nbj ifg25_nbj B[51] VSS VSS nmos_lvt l=16n nfin=2
MP_ifg25_nbj ifg25_nbj B[51] VDD VDD pmos_lvt l=16n nfin=2
MP_q01_fg25 ifg25_x0 ifg25_nai ifg25_q0p1 VDD pmos_lvt l=16n nfin=2
MP_q02_fg25 ifg25_q0p1 ifg25_nbi VDD VDD pmos_lvt l=16n nfin=2
MP_q03_fg25 ifg25_x0 A[50] ifg25_q0p2 VDD pmos_lvt l=16n nfin=2
MP_q04_fg25 ifg25_q0p2 B[50] VDD VDD pmos_lvt l=16n nfin=2
MN_q01_fg25 ifg25_q0n ifg25_nai VSS VSS nmos_lvt l=16n nfin=2
MN_q02_fg25 ifg25_q0n ifg25_nbi VSS VSS nmos_lvt l=16n nfin=2
MN_q03_fg25 ifg25_x0 A[50] ifg25_q0n VSS nmos_lvt l=16n nfin=2
MN_q04_fg25 ifg25_x0 B[50] ifg25_q0n VSS nmos_lvt l=16n nfin=2
MP_q11_fg25 ifg25_x1 ifg25_naj ifg25_q1p1 VDD pmos_lvt l=16n nfin=2
MP_q12_fg25 ifg25_q1p1 ifg25_nbj VDD VDD pmos_lvt l=16n nfin=2
MP_q13_fg25 ifg25_x1 A[51] ifg25_q1p2 VDD pmos_lvt l=16n nfin=2
MP_q14_fg25 ifg25_q1p2 B[51] VDD VDD pmos_lvt l=16n nfin=2
MN_q11_fg25 ifg25_q1n ifg25_naj VSS VSS nmos_lvt l=16n nfin=2
MN_q12_fg25 ifg25_q1n ifg25_nbj VSS VSS nmos_lvt l=16n nfin=2
MN_q13_fg25 ifg25_x1 A[51] ifg25_q1n VSS nmos_lvt l=16n nfin=2
MN_q14_fg25 ifg25_x1 B[51] ifg25_q1n VSS nmos_lvt l=16n nfin=2
MN_ix0_fg25 ifg25_d0 ifg25_x0 VSS VSS nmos_lvt l=16n nfin=2
MP_ix0_fg25 ifg25_d0 ifg25_x0 VDD VDD pmos_lvt l=16n nfin=2
MN_ix1_fg25 ifg25_d1 ifg25_x1 VSS VSS nmos_lvt l=16n nfin=2
MP_ix1_fg25 ifg25_d1 ifg25_x1 VDD VDD pmos_lvt l=16n nfin=2
MP_a11_fg25 ifg25_a1p ifg25_d0 VDD VDD pmos_lvt l=16n nfin=2
MP_a12_fg25 ifg25_a1p ifg25_x1 VDD VDD pmos_lvt l=16n nfin=2
MP_a13_fg25 noh1[25] ifg25_x0 ifg25_a1p VDD pmos_lvt l=16n nfin=2
MP_a14_fg25 noh1[25] ifg25_d1 ifg25_a1p VDD pmos_lvt l=16n nfin=2
MN_a11_fg25 noh1[25] ifg25_d0 ifg25_a1n1 VSS nmos_lvt l=16n nfin=2
MN_a12_fg25 ifg25_a1n1 ifg25_x1 VSS VSS nmos_lvt l=16n nfin=2
MN_a13_fg25 noh1[25] ifg25_x0 ifg25_a1n2 VSS nmos_lvt l=16n nfin=2
MN_a14_fg25 ifg25_a1n2 ifg25_d1 VSS VSS nmos_lvt l=16n nfin=2
MP_n21_fg25 noh2[25] ifg25_d0 VDD VDD pmos_lvt l=16n nfin=2
MP_n22_fg25 noh2[25] ifg25_d1 VDD VDD pmos_lvt l=16n nfin=2
MN_n21_fg25 noh2[25] ifg25_d0 ifg25_n2s VSS nmos_lvt l=16n nfin=2
MN_n22_fg25 ifg25_n2s ifg25_d1 VSS VSS nmos_lvt l=16n nfin=2

* FUSED_G fg26 (40T, ASAP5 extracted: W=0.45u L=0.16u)
MN_ifg26_nai ifg26_nai A[52] VSS VSS nmos_lvt l=16n nfin=2
MP_ifg26_nai ifg26_nai A[52] VDD VDD pmos_lvt l=16n nfin=2
MN_ifg26_nbi ifg26_nbi B[52] VSS VSS nmos_lvt l=16n nfin=2
MP_ifg26_nbi ifg26_nbi B[52] VDD VDD pmos_lvt l=16n nfin=2
MN_ifg26_naj ifg26_naj A[53] VSS VSS nmos_lvt l=16n nfin=2
MP_ifg26_naj ifg26_naj A[53] VDD VDD pmos_lvt l=16n nfin=2
MN_ifg26_nbj ifg26_nbj B[53] VSS VSS nmos_lvt l=16n nfin=2
MP_ifg26_nbj ifg26_nbj B[53] VDD VDD pmos_lvt l=16n nfin=2
MP_q01_fg26 ifg26_x0 ifg26_nai ifg26_q0p1 VDD pmos_lvt l=16n nfin=2
MP_q02_fg26 ifg26_q0p1 ifg26_nbi VDD VDD pmos_lvt l=16n nfin=2
MP_q03_fg26 ifg26_x0 A[52] ifg26_q0p2 VDD pmos_lvt l=16n nfin=2
MP_q04_fg26 ifg26_q0p2 B[52] VDD VDD pmos_lvt l=16n nfin=2
MN_q01_fg26 ifg26_q0n ifg26_nai VSS VSS nmos_lvt l=16n nfin=2
MN_q02_fg26 ifg26_q0n ifg26_nbi VSS VSS nmos_lvt l=16n nfin=2
MN_q03_fg26 ifg26_x0 A[52] ifg26_q0n VSS nmos_lvt l=16n nfin=2
MN_q04_fg26 ifg26_x0 B[52] ifg26_q0n VSS nmos_lvt l=16n nfin=2
MP_q11_fg26 ifg26_x1 ifg26_naj ifg26_q1p1 VDD pmos_lvt l=16n nfin=2
MP_q12_fg26 ifg26_q1p1 ifg26_nbj VDD VDD pmos_lvt l=16n nfin=2
MP_q13_fg26 ifg26_x1 A[53] ifg26_q1p2 VDD pmos_lvt l=16n nfin=2
MP_q14_fg26 ifg26_q1p2 B[53] VDD VDD pmos_lvt l=16n nfin=2
MN_q11_fg26 ifg26_q1n ifg26_naj VSS VSS nmos_lvt l=16n nfin=2
MN_q12_fg26 ifg26_q1n ifg26_nbj VSS VSS nmos_lvt l=16n nfin=2
MN_q13_fg26 ifg26_x1 A[53] ifg26_q1n VSS nmos_lvt l=16n nfin=2
MN_q14_fg26 ifg26_x1 B[53] ifg26_q1n VSS nmos_lvt l=16n nfin=2
MN_ix0_fg26 ifg26_d0 ifg26_x0 VSS VSS nmos_lvt l=16n nfin=2
MP_ix0_fg26 ifg26_d0 ifg26_x0 VDD VDD pmos_lvt l=16n nfin=2
MN_ix1_fg26 ifg26_d1 ifg26_x1 VSS VSS nmos_lvt l=16n nfin=2
MP_ix1_fg26 ifg26_d1 ifg26_x1 VDD VDD pmos_lvt l=16n nfin=2
MP_a11_fg26 ifg26_a1p ifg26_d0 VDD VDD pmos_lvt l=16n nfin=2
MP_a12_fg26 ifg26_a1p ifg26_x1 VDD VDD pmos_lvt l=16n nfin=2
MP_a13_fg26 noh1[26] ifg26_x0 ifg26_a1p VDD pmos_lvt l=16n nfin=2
MP_a14_fg26 noh1[26] ifg26_d1 ifg26_a1p VDD pmos_lvt l=16n nfin=2
MN_a11_fg26 noh1[26] ifg26_d0 ifg26_a1n1 VSS nmos_lvt l=16n nfin=2
MN_a12_fg26 ifg26_a1n1 ifg26_x1 VSS VSS nmos_lvt l=16n nfin=2
MN_a13_fg26 noh1[26] ifg26_x0 ifg26_a1n2 VSS nmos_lvt l=16n nfin=2
MN_a14_fg26 ifg26_a1n2 ifg26_d1 VSS VSS nmos_lvt l=16n nfin=2
MP_n21_fg26 noh2[26] ifg26_d0 VDD VDD pmos_lvt l=16n nfin=2
MP_n22_fg26 noh2[26] ifg26_d1 VDD VDD pmos_lvt l=16n nfin=2
MN_n21_fg26 noh2[26] ifg26_d0 ifg26_n2s VSS nmos_lvt l=16n nfin=2
MN_n22_fg26 ifg26_n2s ifg26_d1 VSS VSS nmos_lvt l=16n nfin=2

* FUSED_G fg27 (40T, ASAP5 extracted: W=0.45u L=0.16u)
MN_ifg27_nai ifg27_nai A[54] VSS VSS nmos_lvt l=16n nfin=2
MP_ifg27_nai ifg27_nai A[54] VDD VDD pmos_lvt l=16n nfin=2
MN_ifg27_nbi ifg27_nbi B[54] VSS VSS nmos_lvt l=16n nfin=2
MP_ifg27_nbi ifg27_nbi B[54] VDD VDD pmos_lvt l=16n nfin=2
MN_ifg27_naj ifg27_naj A[55] VSS VSS nmos_lvt l=16n nfin=2
MP_ifg27_naj ifg27_naj A[55] VDD VDD pmos_lvt l=16n nfin=2
MN_ifg27_nbj ifg27_nbj B[55] VSS VSS nmos_lvt l=16n nfin=2
MP_ifg27_nbj ifg27_nbj B[55] VDD VDD pmos_lvt l=16n nfin=2
MP_q01_fg27 ifg27_x0 ifg27_nai ifg27_q0p1 VDD pmos_lvt l=16n nfin=2
MP_q02_fg27 ifg27_q0p1 ifg27_nbi VDD VDD pmos_lvt l=16n nfin=2
MP_q03_fg27 ifg27_x0 A[54] ifg27_q0p2 VDD pmos_lvt l=16n nfin=2
MP_q04_fg27 ifg27_q0p2 B[54] VDD VDD pmos_lvt l=16n nfin=2
MN_q01_fg27 ifg27_q0n ifg27_nai VSS VSS nmos_lvt l=16n nfin=2
MN_q02_fg27 ifg27_q0n ifg27_nbi VSS VSS nmos_lvt l=16n nfin=2
MN_q03_fg27 ifg27_x0 A[54] ifg27_q0n VSS nmos_lvt l=16n nfin=2
MN_q04_fg27 ifg27_x0 B[54] ifg27_q0n VSS nmos_lvt l=16n nfin=2
MP_q11_fg27 ifg27_x1 ifg27_naj ifg27_q1p1 VDD pmos_lvt l=16n nfin=2
MP_q12_fg27 ifg27_q1p1 ifg27_nbj VDD VDD pmos_lvt l=16n nfin=2
MP_q13_fg27 ifg27_x1 A[55] ifg27_q1p2 VDD pmos_lvt l=16n nfin=2
MP_q14_fg27 ifg27_q1p2 B[55] VDD VDD pmos_lvt l=16n nfin=2
MN_q11_fg27 ifg27_q1n ifg27_naj VSS VSS nmos_lvt l=16n nfin=2
MN_q12_fg27 ifg27_q1n ifg27_nbj VSS VSS nmos_lvt l=16n nfin=2
MN_q13_fg27 ifg27_x1 A[55] ifg27_q1n VSS nmos_lvt l=16n nfin=2
MN_q14_fg27 ifg27_x1 B[55] ifg27_q1n VSS nmos_lvt l=16n nfin=2
MN_ix0_fg27 ifg27_d0 ifg27_x0 VSS VSS nmos_lvt l=16n nfin=2
MP_ix0_fg27 ifg27_d0 ifg27_x0 VDD VDD pmos_lvt l=16n nfin=2
MN_ix1_fg27 ifg27_d1 ifg27_x1 VSS VSS nmos_lvt l=16n nfin=2
MP_ix1_fg27 ifg27_d1 ifg27_x1 VDD VDD pmos_lvt l=16n nfin=2
MP_a11_fg27 ifg27_a1p ifg27_d0 VDD VDD pmos_lvt l=16n nfin=2
MP_a12_fg27 ifg27_a1p ifg27_x1 VDD VDD pmos_lvt l=16n nfin=2
MP_a13_fg27 noh1[27] ifg27_x0 ifg27_a1p VDD pmos_lvt l=16n nfin=2
MP_a14_fg27 noh1[27] ifg27_d1 ifg27_a1p VDD pmos_lvt l=16n nfin=2
MN_a11_fg27 noh1[27] ifg27_d0 ifg27_a1n1 VSS nmos_lvt l=16n nfin=2
MN_a12_fg27 ifg27_a1n1 ifg27_x1 VSS VSS nmos_lvt l=16n nfin=2
MN_a13_fg27 noh1[27] ifg27_x0 ifg27_a1n2 VSS nmos_lvt l=16n nfin=2
MN_a14_fg27 ifg27_a1n2 ifg27_d1 VSS VSS nmos_lvt l=16n nfin=2
MP_n21_fg27 noh2[27] ifg27_d0 VDD VDD pmos_lvt l=16n nfin=2
MP_n22_fg27 noh2[27] ifg27_d1 VDD VDD pmos_lvt l=16n nfin=2
MN_n21_fg27 noh2[27] ifg27_d0 ifg27_n2s VSS nmos_lvt l=16n nfin=2
MN_n22_fg27 ifg27_n2s ifg27_d1 VSS VSS nmos_lvt l=16n nfin=2

* FUSED_G fg28 (40T, ASAP5 extracted: W=0.45u L=0.16u)
MN_ifg28_nai ifg28_nai A[56] VSS VSS nmos_lvt l=16n nfin=2
MP_ifg28_nai ifg28_nai A[56] VDD VDD pmos_lvt l=16n nfin=2
MN_ifg28_nbi ifg28_nbi B[56] VSS VSS nmos_lvt l=16n nfin=2
MP_ifg28_nbi ifg28_nbi B[56] VDD VDD pmos_lvt l=16n nfin=2
MN_ifg28_naj ifg28_naj A[57] VSS VSS nmos_lvt l=16n nfin=2
MP_ifg28_naj ifg28_naj A[57] VDD VDD pmos_lvt l=16n nfin=2
MN_ifg28_nbj ifg28_nbj B[57] VSS VSS nmos_lvt l=16n nfin=2
MP_ifg28_nbj ifg28_nbj B[57] VDD VDD pmos_lvt l=16n nfin=2
MP_q01_fg28 ifg28_x0 ifg28_nai ifg28_q0p1 VDD pmos_lvt l=16n nfin=2
MP_q02_fg28 ifg28_q0p1 ifg28_nbi VDD VDD pmos_lvt l=16n nfin=2
MP_q03_fg28 ifg28_x0 A[56] ifg28_q0p2 VDD pmos_lvt l=16n nfin=2
MP_q04_fg28 ifg28_q0p2 B[56] VDD VDD pmos_lvt l=16n nfin=2
MN_q01_fg28 ifg28_q0n ifg28_nai VSS VSS nmos_lvt l=16n nfin=2
MN_q02_fg28 ifg28_q0n ifg28_nbi VSS VSS nmos_lvt l=16n nfin=2
MN_q03_fg28 ifg28_x0 A[56] ifg28_q0n VSS nmos_lvt l=16n nfin=2
MN_q04_fg28 ifg28_x0 B[56] ifg28_q0n VSS nmos_lvt l=16n nfin=2
MP_q11_fg28 ifg28_x1 ifg28_naj ifg28_q1p1 VDD pmos_lvt l=16n nfin=2
MP_q12_fg28 ifg28_q1p1 ifg28_nbj VDD VDD pmos_lvt l=16n nfin=2
MP_q13_fg28 ifg28_x1 A[57] ifg28_q1p2 VDD pmos_lvt l=16n nfin=2
MP_q14_fg28 ifg28_q1p2 B[57] VDD VDD pmos_lvt l=16n nfin=2
MN_q11_fg28 ifg28_q1n ifg28_naj VSS VSS nmos_lvt l=16n nfin=2
MN_q12_fg28 ifg28_q1n ifg28_nbj VSS VSS nmos_lvt l=16n nfin=2
MN_q13_fg28 ifg28_x1 A[57] ifg28_q1n VSS nmos_lvt l=16n nfin=2
MN_q14_fg28 ifg28_x1 B[57] ifg28_q1n VSS nmos_lvt l=16n nfin=2
MN_ix0_fg28 ifg28_d0 ifg28_x0 VSS VSS nmos_lvt l=16n nfin=2
MP_ix0_fg28 ifg28_d0 ifg28_x0 VDD VDD pmos_lvt l=16n nfin=2
MN_ix1_fg28 ifg28_d1 ifg28_x1 VSS VSS nmos_lvt l=16n nfin=2
MP_ix1_fg28 ifg28_d1 ifg28_x1 VDD VDD pmos_lvt l=16n nfin=2
MP_a11_fg28 ifg28_a1p ifg28_d0 VDD VDD pmos_lvt l=16n nfin=2
MP_a12_fg28 ifg28_a1p ifg28_x1 VDD VDD pmos_lvt l=16n nfin=2
MP_a13_fg28 noh1[28] ifg28_x0 ifg28_a1p VDD pmos_lvt l=16n nfin=2
MP_a14_fg28 noh1[28] ifg28_d1 ifg28_a1p VDD pmos_lvt l=16n nfin=2
MN_a11_fg28 noh1[28] ifg28_d0 ifg28_a1n1 VSS nmos_lvt l=16n nfin=2
MN_a12_fg28 ifg28_a1n1 ifg28_x1 VSS VSS nmos_lvt l=16n nfin=2
MN_a13_fg28 noh1[28] ifg28_x0 ifg28_a1n2 VSS nmos_lvt l=16n nfin=2
MN_a14_fg28 ifg28_a1n2 ifg28_d1 VSS VSS nmos_lvt l=16n nfin=2
MP_n21_fg28 noh2[28] ifg28_d0 VDD VDD pmos_lvt l=16n nfin=2
MP_n22_fg28 noh2[28] ifg28_d1 VDD VDD pmos_lvt l=16n nfin=2
MN_n21_fg28 noh2[28] ifg28_d0 ifg28_n2s VSS nmos_lvt l=16n nfin=2
MN_n22_fg28 ifg28_n2s ifg28_d1 VSS VSS nmos_lvt l=16n nfin=2

* FUSED_G fg29 (40T, ASAP5 extracted: W=0.45u L=0.16u)
MN_ifg29_nai ifg29_nai A[58] VSS VSS nmos_lvt l=16n nfin=2
MP_ifg29_nai ifg29_nai A[58] VDD VDD pmos_lvt l=16n nfin=2
MN_ifg29_nbi ifg29_nbi B[58] VSS VSS nmos_lvt l=16n nfin=2
MP_ifg29_nbi ifg29_nbi B[58] VDD VDD pmos_lvt l=16n nfin=2
MN_ifg29_naj ifg29_naj A[59] VSS VSS nmos_lvt l=16n nfin=2
MP_ifg29_naj ifg29_naj A[59] VDD VDD pmos_lvt l=16n nfin=2
MN_ifg29_nbj ifg29_nbj B[59] VSS VSS nmos_lvt l=16n nfin=2
MP_ifg29_nbj ifg29_nbj B[59] VDD VDD pmos_lvt l=16n nfin=2
MP_q01_fg29 ifg29_x0 ifg29_nai ifg29_q0p1 VDD pmos_lvt l=16n nfin=2
MP_q02_fg29 ifg29_q0p1 ifg29_nbi VDD VDD pmos_lvt l=16n nfin=2
MP_q03_fg29 ifg29_x0 A[58] ifg29_q0p2 VDD pmos_lvt l=16n nfin=2
MP_q04_fg29 ifg29_q0p2 B[58] VDD VDD pmos_lvt l=16n nfin=2
MN_q01_fg29 ifg29_q0n ifg29_nai VSS VSS nmos_lvt l=16n nfin=2
MN_q02_fg29 ifg29_q0n ifg29_nbi VSS VSS nmos_lvt l=16n nfin=2
MN_q03_fg29 ifg29_x0 A[58] ifg29_q0n VSS nmos_lvt l=16n nfin=2
MN_q04_fg29 ifg29_x0 B[58] ifg29_q0n VSS nmos_lvt l=16n nfin=2
MP_q11_fg29 ifg29_x1 ifg29_naj ifg29_q1p1 VDD pmos_lvt l=16n nfin=2
MP_q12_fg29 ifg29_q1p1 ifg29_nbj VDD VDD pmos_lvt l=16n nfin=2
MP_q13_fg29 ifg29_x1 A[59] ifg29_q1p2 VDD pmos_lvt l=16n nfin=2
MP_q14_fg29 ifg29_q1p2 B[59] VDD VDD pmos_lvt l=16n nfin=2
MN_q11_fg29 ifg29_q1n ifg29_naj VSS VSS nmos_lvt l=16n nfin=2
MN_q12_fg29 ifg29_q1n ifg29_nbj VSS VSS nmos_lvt l=16n nfin=2
MN_q13_fg29 ifg29_x1 A[59] ifg29_q1n VSS nmos_lvt l=16n nfin=2
MN_q14_fg29 ifg29_x1 B[59] ifg29_q1n VSS nmos_lvt l=16n nfin=2
MN_ix0_fg29 ifg29_d0 ifg29_x0 VSS VSS nmos_lvt l=16n nfin=2
MP_ix0_fg29 ifg29_d0 ifg29_x0 VDD VDD pmos_lvt l=16n nfin=2
MN_ix1_fg29 ifg29_d1 ifg29_x1 VSS VSS nmos_lvt l=16n nfin=2
MP_ix1_fg29 ifg29_d1 ifg29_x1 VDD VDD pmos_lvt l=16n nfin=2
MP_a11_fg29 ifg29_a1p ifg29_d0 VDD VDD pmos_lvt l=16n nfin=2
MP_a12_fg29 ifg29_a1p ifg29_x1 VDD VDD pmos_lvt l=16n nfin=2
MP_a13_fg29 noh1[29] ifg29_x0 ifg29_a1p VDD pmos_lvt l=16n nfin=2
MP_a14_fg29 noh1[29] ifg29_d1 ifg29_a1p VDD pmos_lvt l=16n nfin=2
MN_a11_fg29 noh1[29] ifg29_d0 ifg29_a1n1 VSS nmos_lvt l=16n nfin=2
MN_a12_fg29 ifg29_a1n1 ifg29_x1 VSS VSS nmos_lvt l=16n nfin=2
MN_a13_fg29 noh1[29] ifg29_x0 ifg29_a1n2 VSS nmos_lvt l=16n nfin=2
MN_a14_fg29 ifg29_a1n2 ifg29_d1 VSS VSS nmos_lvt l=16n nfin=2
MP_n21_fg29 noh2[29] ifg29_d0 VDD VDD pmos_lvt l=16n nfin=2
MP_n22_fg29 noh2[29] ifg29_d1 VDD VDD pmos_lvt l=16n nfin=2
MN_n21_fg29 noh2[29] ifg29_d0 ifg29_n2s VSS nmos_lvt l=16n nfin=2
MN_n22_fg29 ifg29_n2s ifg29_d1 VSS VSS nmos_lvt l=16n nfin=2

* FUSED_G fg30 (40T, ASAP5 extracted: W=0.45u L=0.16u)
MN_ifg30_nai ifg30_nai A[60] VSS VSS nmos_lvt l=16n nfin=2
MP_ifg30_nai ifg30_nai A[60] VDD VDD pmos_lvt l=16n nfin=2
MN_ifg30_nbi ifg30_nbi B[60] VSS VSS nmos_lvt l=16n nfin=2
MP_ifg30_nbi ifg30_nbi B[60] VDD VDD pmos_lvt l=16n nfin=2
MN_ifg30_naj ifg30_naj A[61] VSS VSS nmos_lvt l=16n nfin=2
MP_ifg30_naj ifg30_naj A[61] VDD VDD pmos_lvt l=16n nfin=2
MN_ifg30_nbj ifg30_nbj B[61] VSS VSS nmos_lvt l=16n nfin=2
MP_ifg30_nbj ifg30_nbj B[61] VDD VDD pmos_lvt l=16n nfin=2
MP_q01_fg30 ifg30_x0 ifg30_nai ifg30_q0p1 VDD pmos_lvt l=16n nfin=2
MP_q02_fg30 ifg30_q0p1 ifg30_nbi VDD VDD pmos_lvt l=16n nfin=2
MP_q03_fg30 ifg30_x0 A[60] ifg30_q0p2 VDD pmos_lvt l=16n nfin=2
MP_q04_fg30 ifg30_q0p2 B[60] VDD VDD pmos_lvt l=16n nfin=2
MN_q01_fg30 ifg30_q0n ifg30_nai VSS VSS nmos_lvt l=16n nfin=2
MN_q02_fg30 ifg30_q0n ifg30_nbi VSS VSS nmos_lvt l=16n nfin=2
MN_q03_fg30 ifg30_x0 A[60] ifg30_q0n VSS nmos_lvt l=16n nfin=2
MN_q04_fg30 ifg30_x0 B[60] ifg30_q0n VSS nmos_lvt l=16n nfin=2
MP_q11_fg30 ifg30_x1 ifg30_naj ifg30_q1p1 VDD pmos_lvt l=16n nfin=2
MP_q12_fg30 ifg30_q1p1 ifg30_nbj VDD VDD pmos_lvt l=16n nfin=2
MP_q13_fg30 ifg30_x1 A[61] ifg30_q1p2 VDD pmos_lvt l=16n nfin=2
MP_q14_fg30 ifg30_q1p2 B[61] VDD VDD pmos_lvt l=16n nfin=2
MN_q11_fg30 ifg30_q1n ifg30_naj VSS VSS nmos_lvt l=16n nfin=2
MN_q12_fg30 ifg30_q1n ifg30_nbj VSS VSS nmos_lvt l=16n nfin=2
MN_q13_fg30 ifg30_x1 A[61] ifg30_q1n VSS nmos_lvt l=16n nfin=2
MN_q14_fg30 ifg30_x1 B[61] ifg30_q1n VSS nmos_lvt l=16n nfin=2
MN_ix0_fg30 ifg30_d0 ifg30_x0 VSS VSS nmos_lvt l=16n nfin=2
MP_ix0_fg30 ifg30_d0 ifg30_x0 VDD VDD pmos_lvt l=16n nfin=2
MN_ix1_fg30 ifg30_d1 ifg30_x1 VSS VSS nmos_lvt l=16n nfin=2
MP_ix1_fg30 ifg30_d1 ifg30_x1 VDD VDD pmos_lvt l=16n nfin=2
MP_a11_fg30 ifg30_a1p ifg30_d0 VDD VDD pmos_lvt l=16n nfin=2
MP_a12_fg30 ifg30_a1p ifg30_x1 VDD VDD pmos_lvt l=16n nfin=2
MP_a13_fg30 noh1[30] ifg30_x0 ifg30_a1p VDD pmos_lvt l=16n nfin=2
MP_a14_fg30 noh1[30] ifg30_d1 ifg30_a1p VDD pmos_lvt l=16n nfin=2
MN_a11_fg30 noh1[30] ifg30_d0 ifg30_a1n1 VSS nmos_lvt l=16n nfin=2
MN_a12_fg30 ifg30_a1n1 ifg30_x1 VSS VSS nmos_lvt l=16n nfin=2
MN_a13_fg30 noh1[30] ifg30_x0 ifg30_a1n2 VSS nmos_lvt l=16n nfin=2
MN_a14_fg30 ifg30_a1n2 ifg30_d1 VSS VSS nmos_lvt l=16n nfin=2
MP_n21_fg30 noh2[30] ifg30_d0 VDD VDD pmos_lvt l=16n nfin=2
MP_n22_fg30 noh2[30] ifg30_d1 VDD VDD pmos_lvt l=16n nfin=2
MN_n21_fg30 noh2[30] ifg30_d0 ifg30_n2s VSS nmos_lvt l=16n nfin=2
MN_n22_fg30 ifg30_n2s ifg30_d1 VSS VSS nmos_lvt l=16n nfin=2

* FUSED_G fg31 (40T, ASAP5 extracted: W=0.45u L=0.16u)
MN_ifg31_nai ifg31_nai A[62] VSS VSS nmos_lvt l=16n nfin=2
MP_ifg31_nai ifg31_nai A[62] VDD VDD pmos_lvt l=16n nfin=2
MN_ifg31_nbi ifg31_nbi B[62] VSS VSS nmos_lvt l=16n nfin=2
MP_ifg31_nbi ifg31_nbi B[62] VDD VDD pmos_lvt l=16n nfin=2
MN_ifg31_naj ifg31_naj A[63] VSS VSS nmos_lvt l=16n nfin=2
MP_ifg31_naj ifg31_naj A[63] VDD VDD pmos_lvt l=16n nfin=2
MN_ifg31_nbj ifg31_nbj B[63] VSS VSS nmos_lvt l=16n nfin=2
MP_ifg31_nbj ifg31_nbj B[63] VDD VDD pmos_lvt l=16n nfin=2
MP_q01_fg31 ifg31_x0 ifg31_nai ifg31_q0p1 VDD pmos_lvt l=16n nfin=2
MP_q02_fg31 ifg31_q0p1 ifg31_nbi VDD VDD pmos_lvt l=16n nfin=2
MP_q03_fg31 ifg31_x0 A[62] ifg31_q0p2 VDD pmos_lvt l=16n nfin=2
MP_q04_fg31 ifg31_q0p2 B[62] VDD VDD pmos_lvt l=16n nfin=2
MN_q01_fg31 ifg31_q0n ifg31_nai VSS VSS nmos_lvt l=16n nfin=2
MN_q02_fg31 ifg31_q0n ifg31_nbi VSS VSS nmos_lvt l=16n nfin=2
MN_q03_fg31 ifg31_x0 A[62] ifg31_q0n VSS nmos_lvt l=16n nfin=2
MN_q04_fg31 ifg31_x0 B[62] ifg31_q0n VSS nmos_lvt l=16n nfin=2
MP_q11_fg31 ifg31_x1 ifg31_naj ifg31_q1p1 VDD pmos_lvt l=16n nfin=2
MP_q12_fg31 ifg31_q1p1 ifg31_nbj VDD VDD pmos_lvt l=16n nfin=2
MP_q13_fg31 ifg31_x1 A[63] ifg31_q1p2 VDD pmos_lvt l=16n nfin=2
MP_q14_fg31 ifg31_q1p2 B[63] VDD VDD pmos_lvt l=16n nfin=2
MN_q11_fg31 ifg31_q1n ifg31_naj VSS VSS nmos_lvt l=16n nfin=2
MN_q12_fg31 ifg31_q1n ifg31_nbj VSS VSS nmos_lvt l=16n nfin=2
MN_q13_fg31 ifg31_x1 A[63] ifg31_q1n VSS nmos_lvt l=16n nfin=2
MN_q14_fg31 ifg31_x1 B[63] ifg31_q1n VSS nmos_lvt l=16n nfin=2
MN_ix0_fg31 ifg31_d0 ifg31_x0 VSS VSS nmos_lvt l=16n nfin=2
MP_ix0_fg31 ifg31_d0 ifg31_x0 VDD VDD pmos_lvt l=16n nfin=2
MN_ix1_fg31 ifg31_d1 ifg31_x1 VSS VSS nmos_lvt l=16n nfin=2
MP_ix1_fg31 ifg31_d1 ifg31_x1 VDD VDD pmos_lvt l=16n nfin=2
MP_a11_fg31 ifg31_a1p ifg31_d0 VDD VDD pmos_lvt l=16n nfin=2
MP_a12_fg31 ifg31_a1p ifg31_x1 VDD VDD pmos_lvt l=16n nfin=2
MP_a13_fg31 noh1[31] ifg31_x0 ifg31_a1p VDD pmos_lvt l=16n nfin=2
MP_a14_fg31 noh1[31] ifg31_d1 ifg31_a1p VDD pmos_lvt l=16n nfin=2
MN_a11_fg31 noh1[31] ifg31_d0 ifg31_a1n1 VSS nmos_lvt l=16n nfin=2
MN_a12_fg31 ifg31_a1n1 ifg31_x1 VSS VSS nmos_lvt l=16n nfin=2
MN_a13_fg31 noh1[31] ifg31_x0 ifg31_a1n2 VSS nmos_lvt l=16n nfin=2
MN_a14_fg31 ifg31_a1n2 ifg31_d1 VSS VSS nmos_lvt l=16n nfin=2
MP_n21_fg31 noh2[31] ifg31_d0 VDD VDD pmos_lvt l=16n nfin=2
MP_n22_fg31 noh2[31] ifg31_d1 VDD VDD pmos_lvt l=16n nfin=2
MN_n21_fg31 noh2[31] ifg31_d0 ifg31_n2s VSS nmos_lvt l=16n nfin=2
MN_n22_fg31 ifg31_n2s ifg31_d1 VSS VSS nmos_lvt l=16n nfin=2

MP_iv00a oh1[0] noh1[0] VDD VDD pmos_lvt l=14n nfin=2
MN_iv00a oh1[0] noh1[0] VSS VSS nmos_lvt l=14n nfin=2
MP_iv00b oh2[0] noh2[0] VDD VDD pmos_lvt l=14n nfin=2
MN_iv00b oh2[0] noh2[0] VSS VSS nmos_lvt l=14n nfin=2
MP_iv01a oh1[1] noh1[1] VDD VDD pmos_lvt l=14n nfin=2
MN_iv01a oh1[1] noh1[1] VSS VSS nmos_lvt l=14n nfin=2
MP_iv01b oh2[1] noh2[1] VDD VDD pmos_lvt l=14n nfin=2
MN_iv01b oh2[1] noh2[1] VSS VSS nmos_lvt l=14n nfin=2
MP_iv02a oh1[2] noh1[2] VDD VDD pmos_lvt l=14n nfin=2
MN_iv02a oh1[2] noh1[2] VSS VSS nmos_lvt l=14n nfin=2
MP_iv02b oh2[2] noh2[2] VDD VDD pmos_lvt l=14n nfin=2
MN_iv02b oh2[2] noh2[2] VSS VSS nmos_lvt l=14n nfin=2
MP_iv03a oh1[3] noh1[3] VDD VDD pmos_lvt l=14n nfin=2
MN_iv03a oh1[3] noh1[3] VSS VSS nmos_lvt l=14n nfin=2
MP_iv03b oh2[3] noh2[3] VDD VDD pmos_lvt l=14n nfin=2
MN_iv03b oh2[3] noh2[3] VSS VSS nmos_lvt l=14n nfin=2
MP_iv04a oh1[4] noh1[4] VDD VDD pmos_lvt l=14n nfin=2
MN_iv04a oh1[4] noh1[4] VSS VSS nmos_lvt l=14n nfin=2
MP_iv04b oh2[4] noh2[4] VDD VDD pmos_lvt l=14n nfin=2
MN_iv04b oh2[4] noh2[4] VSS VSS nmos_lvt l=14n nfin=2
MP_iv05a oh1[5] noh1[5] VDD VDD pmos_lvt l=14n nfin=2
MN_iv05a oh1[5] noh1[5] VSS VSS nmos_lvt l=14n nfin=2
MP_iv05b oh2[5] noh2[5] VDD VDD pmos_lvt l=14n nfin=2
MN_iv05b oh2[5] noh2[5] VSS VSS nmos_lvt l=14n nfin=2
MP_iv06a oh1[6] noh1[6] VDD VDD pmos_lvt l=14n nfin=2
MN_iv06a oh1[6] noh1[6] VSS VSS nmos_lvt l=14n nfin=2
MP_iv06b oh2[6] noh2[6] VDD VDD pmos_lvt l=14n nfin=2
MN_iv06b oh2[6] noh2[6] VSS VSS nmos_lvt l=14n nfin=2
MP_iv07a oh1[7] noh1[7] VDD VDD pmos_lvt l=14n nfin=2
MN_iv07a oh1[7] noh1[7] VSS VSS nmos_lvt l=14n nfin=2
MP_iv07b oh2[7] noh2[7] VDD VDD pmos_lvt l=14n nfin=2
MN_iv07b oh2[7] noh2[7] VSS VSS nmos_lvt l=14n nfin=2
MP_iv08a oh1[8] noh1[8] VDD VDD pmos_lvt l=14n nfin=2
MN_iv08a oh1[8] noh1[8] VSS VSS nmos_lvt l=14n nfin=2
MP_iv08b oh2[8] noh2[8] VDD VDD pmos_lvt l=14n nfin=2
MN_iv08b oh2[8] noh2[8] VSS VSS nmos_lvt l=14n nfin=2
MP_iv09a oh1[9] noh1[9] VDD VDD pmos_lvt l=14n nfin=2
MN_iv09a oh1[9] noh1[9] VSS VSS nmos_lvt l=14n nfin=2
MP_iv09b oh2[9] noh2[9] VDD VDD pmos_lvt l=14n nfin=2
MN_iv09b oh2[9] noh2[9] VSS VSS nmos_lvt l=14n nfin=2
MP_iv10a oh1[10] noh1[10] VDD VDD pmos_lvt l=14n nfin=2
MN_iv10a oh1[10] noh1[10] VSS VSS nmos_lvt l=14n nfin=2
MP_iv10b oh2[10] noh2[10] VDD VDD pmos_lvt l=14n nfin=2
MN_iv10b oh2[10] noh2[10] VSS VSS nmos_lvt l=14n nfin=2
MP_iv11a oh1[11] noh1[11] VDD VDD pmos_lvt l=14n nfin=2
MN_iv11a oh1[11] noh1[11] VSS VSS nmos_lvt l=14n nfin=2
MP_iv11b oh2[11] noh2[11] VDD VDD pmos_lvt l=14n nfin=2
MN_iv11b oh2[11] noh2[11] VSS VSS nmos_lvt l=14n nfin=2
MP_iv12a oh1[12] noh1[12] VDD VDD pmos_lvt l=14n nfin=2
MN_iv12a oh1[12] noh1[12] VSS VSS nmos_lvt l=14n nfin=2
MP_iv12b oh2[12] noh2[12] VDD VDD pmos_lvt l=14n nfin=2
MN_iv12b oh2[12] noh2[12] VSS VSS nmos_lvt l=14n nfin=2
MP_iv13a oh1[13] noh1[13] VDD VDD pmos_lvt l=14n nfin=2
MN_iv13a oh1[13] noh1[13] VSS VSS nmos_lvt l=14n nfin=2
MP_iv13b oh2[13] noh2[13] VDD VDD pmos_lvt l=14n nfin=2
MN_iv13b oh2[13] noh2[13] VSS VSS nmos_lvt l=14n nfin=2
MP_iv14a oh1[14] noh1[14] VDD VDD pmos_lvt l=14n nfin=2
MN_iv14a oh1[14] noh1[14] VSS VSS nmos_lvt l=14n nfin=2
MP_iv14b oh2[14] noh2[14] VDD VDD pmos_lvt l=14n nfin=2
MN_iv14b oh2[14] noh2[14] VSS VSS nmos_lvt l=14n nfin=2
MP_iv15a oh1[15] noh1[15] VDD VDD pmos_lvt l=14n nfin=2
MN_iv15a oh1[15] noh1[15] VSS VSS nmos_lvt l=14n nfin=2
MP_iv15b oh2[15] noh2[15] VDD VDD pmos_lvt l=14n nfin=2
MN_iv15b oh2[15] noh2[15] VSS VSS nmos_lvt l=14n nfin=2
MP_iv16a oh1[16] noh1[16] VDD VDD pmos_lvt l=14n nfin=2
MN_iv16a oh1[16] noh1[16] VSS VSS nmos_lvt l=14n nfin=2
MP_iv16b oh2[16] noh2[16] VDD VDD pmos_lvt l=14n nfin=2
MN_iv16b oh2[16] noh2[16] VSS VSS nmos_lvt l=14n nfin=2
MP_iv17a oh1[17] noh1[17] VDD VDD pmos_lvt l=14n nfin=2
MN_iv17a oh1[17] noh1[17] VSS VSS nmos_lvt l=14n nfin=2
MP_iv17b oh2[17] noh2[17] VDD VDD pmos_lvt l=14n nfin=2
MN_iv17b oh2[17] noh2[17] VSS VSS nmos_lvt l=14n nfin=2
MP_iv18a oh1[18] noh1[18] VDD VDD pmos_lvt l=14n nfin=2
MN_iv18a oh1[18] noh1[18] VSS VSS nmos_lvt l=14n nfin=2
MP_iv18b oh2[18] noh2[18] VDD VDD pmos_lvt l=14n nfin=2
MN_iv18b oh2[18] noh2[18] VSS VSS nmos_lvt l=14n nfin=2
MP_iv19a oh1[19] noh1[19] VDD VDD pmos_lvt l=14n nfin=2
MN_iv19a oh1[19] noh1[19] VSS VSS nmos_lvt l=14n nfin=2
MP_iv19b oh2[19] noh2[19] VDD VDD pmos_lvt l=14n nfin=2
MN_iv19b oh2[19] noh2[19] VSS VSS nmos_lvt l=14n nfin=2
MP_iv20a oh1[20] noh1[20] VDD VDD pmos_lvt l=14n nfin=2
MN_iv20a oh1[20] noh1[20] VSS VSS nmos_lvt l=14n nfin=2
MP_iv20b oh2[20] noh2[20] VDD VDD pmos_lvt l=14n nfin=2
MN_iv20b oh2[20] noh2[20] VSS VSS nmos_lvt l=14n nfin=2
MP_iv21a oh1[21] noh1[21] VDD VDD pmos_lvt l=14n nfin=2
MN_iv21a oh1[21] noh1[21] VSS VSS nmos_lvt l=14n nfin=2
MP_iv21b oh2[21] noh2[21] VDD VDD pmos_lvt l=14n nfin=2
MN_iv21b oh2[21] noh2[21] VSS VSS nmos_lvt l=14n nfin=2
MP_iv22a oh1[22] noh1[22] VDD VDD pmos_lvt l=14n nfin=2
MN_iv22a oh1[22] noh1[22] VSS VSS nmos_lvt l=14n nfin=2
MP_iv22b oh2[22] noh2[22] VDD VDD pmos_lvt l=14n nfin=2
MN_iv22b oh2[22] noh2[22] VSS VSS nmos_lvt l=14n nfin=2
MP_iv23a oh1[23] noh1[23] VDD VDD pmos_lvt l=14n nfin=2
MN_iv23a oh1[23] noh1[23] VSS VSS nmos_lvt l=14n nfin=2
MP_iv23b oh2[23] noh2[23] VDD VDD pmos_lvt l=14n nfin=2
MN_iv23b oh2[23] noh2[23] VSS VSS nmos_lvt l=14n nfin=2
MP_iv24a oh1[24] noh1[24] VDD VDD pmos_lvt l=14n nfin=2
MN_iv24a oh1[24] noh1[24] VSS VSS nmos_lvt l=14n nfin=2
MP_iv24b oh2[24] noh2[24] VDD VDD pmos_lvt l=14n nfin=2
MN_iv24b oh2[24] noh2[24] VSS VSS nmos_lvt l=14n nfin=2
MP_iv25a oh1[25] noh1[25] VDD VDD pmos_lvt l=14n nfin=2
MN_iv25a oh1[25] noh1[25] VSS VSS nmos_lvt l=14n nfin=2
MP_iv25b oh2[25] noh2[25] VDD VDD pmos_lvt l=14n nfin=2
MN_iv25b oh2[25] noh2[25] VSS VSS nmos_lvt l=14n nfin=2
MP_iv26a oh1[26] noh1[26] VDD VDD pmos_lvt l=14n nfin=2
MN_iv26a oh1[26] noh1[26] VSS VSS nmos_lvt l=14n nfin=2
MP_iv26b oh2[26] noh2[26] VDD VDD pmos_lvt l=14n nfin=2
MN_iv26b oh2[26] noh2[26] VSS VSS nmos_lvt l=14n nfin=2
MP_iv27a oh1[27] noh1[27] VDD VDD pmos_lvt l=14n nfin=2
MN_iv27a oh1[27] noh1[27] VSS VSS nmos_lvt l=14n nfin=2
MP_iv27b oh2[27] noh2[27] VDD VDD pmos_lvt l=14n nfin=2
MN_iv27b oh2[27] noh2[27] VSS VSS nmos_lvt l=14n nfin=2
MP_iv28a oh1[28] noh1[28] VDD VDD pmos_lvt l=14n nfin=2
MN_iv28a oh1[28] noh1[28] VSS VSS nmos_lvt l=14n nfin=2
MP_iv28b oh2[28] noh2[28] VDD VDD pmos_lvt l=14n nfin=2
MN_iv28b oh2[28] noh2[28] VSS VSS nmos_lvt l=14n nfin=2
MP_iv29a oh1[29] noh1[29] VDD VDD pmos_lvt l=14n nfin=2
MN_iv29a oh1[29] noh1[29] VSS VSS nmos_lvt l=14n nfin=2
MP_iv29b oh2[29] noh2[29] VDD VDD pmos_lvt l=14n nfin=2
MN_iv29b oh2[29] noh2[29] VSS VSS nmos_lvt l=14n nfin=2
MP_iv30a oh1[30] noh1[30] VDD VDD pmos_lvt l=14n nfin=2
MN_iv30a oh1[30] noh1[30] VSS VSS nmos_lvt l=14n nfin=2
MP_iv30b oh2[30] noh2[30] VDD VDD pmos_lvt l=14n nfin=2
MN_iv30b oh2[30] noh2[30] VSS VSS nmos_lvt l=14n nfin=2
MP_iv31a oh1[31] noh1[31] VDD VDD pmos_lvt l=14n nfin=2
MN_iv31a oh1[31] noh1[31] VSS VSS nmos_lvt l=14n nfin=2
MP_iv31b oh2[31] noh2[31] VDD VDD pmos_lvt l=14n nfin=2
MN_iv31b oh2[31] noh2[31] VSS VSS nmos_lvt l=14n nfin=2
MP0_nr00 VDD oh1[0] mid_nr00 VDD pmos_lvt l=16n nfin=1
MP1_nr00 mid_nr00 oh2[0] oh0[0] VDD pmos_lvt l=16n nfin=1
MN0_nr00 oh0[0] oh1[0] VSS VSS nmos_lvt l=16n nfin=1
MN1_nr00 oh0[0] oh2[0] VSS VSS nmos_lvt l=16n nfin=1
MP0_nr01 VDD oh1[1] mid_nr01 VDD pmos_lvt l=16n nfin=1
MP1_nr01 mid_nr01 oh2[1] oh0[1] VDD pmos_lvt l=16n nfin=1
MN0_nr01 oh0[1] oh1[1] VSS VSS nmos_lvt l=16n nfin=1
MN1_nr01 oh0[1] oh2[1] VSS VSS nmos_lvt l=16n nfin=1
MP0_nr02 VDD oh1[2] mid_nr02 VDD pmos_lvt l=16n nfin=1
MP1_nr02 mid_nr02 oh2[2] oh0[2] VDD pmos_lvt l=16n nfin=1
MN0_nr02 oh0[2] oh1[2] VSS VSS nmos_lvt l=16n nfin=1
MN1_nr02 oh0[2] oh2[2] VSS VSS nmos_lvt l=16n nfin=1
MP0_nr03 VDD oh1[3] mid_nr03 VDD pmos_lvt l=16n nfin=1
MP1_nr03 mid_nr03 oh2[3] oh0[3] VDD pmos_lvt l=16n nfin=1
MN0_nr03 oh0[3] oh1[3] VSS VSS nmos_lvt l=16n nfin=1
MN1_nr03 oh0[3] oh2[3] VSS VSS nmos_lvt l=16n nfin=1
MP0_nr04 VDD oh1[4] mid_nr04 VDD pmos_lvt l=16n nfin=1
MP1_nr04 mid_nr04 oh2[4] oh0[4] VDD pmos_lvt l=16n nfin=1
MN0_nr04 oh0[4] oh1[4] VSS VSS nmos_lvt l=16n nfin=1
MN1_nr04 oh0[4] oh2[4] VSS VSS nmos_lvt l=16n nfin=1
MP0_nr05 VDD oh1[5] mid_nr05 VDD pmos_lvt l=16n nfin=1
MP1_nr05 mid_nr05 oh2[5] oh0[5] VDD pmos_lvt l=16n nfin=1
MN0_nr05 oh0[5] oh1[5] VSS VSS nmos_lvt l=16n nfin=1
MN1_nr05 oh0[5] oh2[5] VSS VSS nmos_lvt l=16n nfin=1
MP0_nr06 VDD oh1[6] mid_nr06 VDD pmos_lvt l=16n nfin=1
MP1_nr06 mid_nr06 oh2[6] oh0[6] VDD pmos_lvt l=16n nfin=1
MN0_nr06 oh0[6] oh1[6] VSS VSS nmos_lvt l=16n nfin=1
MN1_nr06 oh0[6] oh2[6] VSS VSS nmos_lvt l=16n nfin=1
MP0_nr07 VDD oh1[7] mid_nr07 VDD pmos_lvt l=16n nfin=1
MP1_nr07 mid_nr07 oh2[7] oh0[7] VDD pmos_lvt l=16n nfin=1
MN0_nr07 oh0[7] oh1[7] VSS VSS nmos_lvt l=16n nfin=1
MN1_nr07 oh0[7] oh2[7] VSS VSS nmos_lvt l=16n nfin=1
MP0_nr08 VDD oh1[8] mid_nr08 VDD pmos_lvt l=16n nfin=1
MP1_nr08 mid_nr08 oh2[8] oh0[8] VDD pmos_lvt l=16n nfin=1
MN0_nr08 oh0[8] oh1[8] VSS VSS nmos_lvt l=16n nfin=1
MN1_nr08 oh0[8] oh2[8] VSS VSS nmos_lvt l=16n nfin=1
MP0_nr09 VDD oh1[9] mid_nr09 VDD pmos_lvt l=16n nfin=1
MP1_nr09 mid_nr09 oh2[9] oh0[9] VDD pmos_lvt l=16n nfin=1
MN0_nr09 oh0[9] oh1[9] VSS VSS nmos_lvt l=16n nfin=1
MN1_nr09 oh0[9] oh2[9] VSS VSS nmos_lvt l=16n nfin=1
MP0_nr10 VDD oh1[10] mid_nr10 VDD pmos_lvt l=16n nfin=1
MP1_nr10 mid_nr10 oh2[10] oh0[10] VDD pmos_lvt l=16n nfin=1
MN0_nr10 oh0[10] oh1[10] VSS VSS nmos_lvt l=16n nfin=1
MN1_nr10 oh0[10] oh2[10] VSS VSS nmos_lvt l=16n nfin=1
MP0_nr11 VDD oh1[11] mid_nr11 VDD pmos_lvt l=16n nfin=1
MP1_nr11 mid_nr11 oh2[11] oh0[11] VDD pmos_lvt l=16n nfin=1
MN0_nr11 oh0[11] oh1[11] VSS VSS nmos_lvt l=16n nfin=1
MN1_nr11 oh0[11] oh2[11] VSS VSS nmos_lvt l=16n nfin=1
MP0_nr12 VDD oh1[12] mid_nr12 VDD pmos_lvt l=16n nfin=1
MP1_nr12 mid_nr12 oh2[12] oh0[12] VDD pmos_lvt l=16n nfin=1
MN0_nr12 oh0[12] oh1[12] VSS VSS nmos_lvt l=16n nfin=1
MN1_nr12 oh0[12] oh2[12] VSS VSS nmos_lvt l=16n nfin=1
MP0_nr13 VDD oh1[13] mid_nr13 VDD pmos_lvt l=16n nfin=1
MP1_nr13 mid_nr13 oh2[13] oh0[13] VDD pmos_lvt l=16n nfin=1
MN0_nr13 oh0[13] oh1[13] VSS VSS nmos_lvt l=16n nfin=1
MN1_nr13 oh0[13] oh2[13] VSS VSS nmos_lvt l=16n nfin=1
MP0_nr14 VDD oh1[14] mid_nr14 VDD pmos_lvt l=16n nfin=1
MP1_nr14 mid_nr14 oh2[14] oh0[14] VDD pmos_lvt l=16n nfin=1
MN0_nr14 oh0[14] oh1[14] VSS VSS nmos_lvt l=16n nfin=1
MN1_nr14 oh0[14] oh2[14] VSS VSS nmos_lvt l=16n nfin=1
MP0_nr15 VDD oh1[15] mid_nr15 VDD pmos_lvt l=16n nfin=1
MP1_nr15 mid_nr15 oh2[15] oh0[15] VDD pmos_lvt l=16n nfin=1
MN0_nr15 oh0[15] oh1[15] VSS VSS nmos_lvt l=16n nfin=1
MN1_nr15 oh0[15] oh2[15] VSS VSS nmos_lvt l=16n nfin=1
MP0_nr16 VDD oh1[16] mid_nr16 VDD pmos_lvt l=16n nfin=1
MP1_nr16 mid_nr16 oh2[16] oh0[16] VDD pmos_lvt l=16n nfin=1
MN0_nr16 oh0[16] oh1[16] VSS VSS nmos_lvt l=16n nfin=1
MN1_nr16 oh0[16] oh2[16] VSS VSS nmos_lvt l=16n nfin=1
MP0_nr17 VDD oh1[17] mid_nr17 VDD pmos_lvt l=16n nfin=1
MP1_nr17 mid_nr17 oh2[17] oh0[17] VDD pmos_lvt l=16n nfin=1
MN0_nr17 oh0[17] oh1[17] VSS VSS nmos_lvt l=16n nfin=1
MN1_nr17 oh0[17] oh2[17] VSS VSS nmos_lvt l=16n nfin=1
MP0_nr18 VDD oh1[18] mid_nr18 VDD pmos_lvt l=16n nfin=1
MP1_nr18 mid_nr18 oh2[18] oh0[18] VDD pmos_lvt l=16n nfin=1
MN0_nr18 oh0[18] oh1[18] VSS VSS nmos_lvt l=16n nfin=1
MN1_nr18 oh0[18] oh2[18] VSS VSS nmos_lvt l=16n nfin=1
MP0_nr19 VDD oh1[19] mid_nr19 VDD pmos_lvt l=16n nfin=1
MP1_nr19 mid_nr19 oh2[19] oh0[19] VDD pmos_lvt l=16n nfin=1
MN0_nr19 oh0[19] oh1[19] VSS VSS nmos_lvt l=16n nfin=1
MN1_nr19 oh0[19] oh2[19] VSS VSS nmos_lvt l=16n nfin=1
MP0_nr20 VDD oh1[20] mid_nr20 VDD pmos_lvt l=16n nfin=1
MP1_nr20 mid_nr20 oh2[20] oh0[20] VDD pmos_lvt l=16n nfin=1
MN0_nr20 oh0[20] oh1[20] VSS VSS nmos_lvt l=16n nfin=1
MN1_nr20 oh0[20] oh2[20] VSS VSS nmos_lvt l=16n nfin=1
MP0_nr21 VDD oh1[21] mid_nr21 VDD pmos_lvt l=16n nfin=1
MP1_nr21 mid_nr21 oh2[21] oh0[21] VDD pmos_lvt l=16n nfin=1
MN0_nr21 oh0[21] oh1[21] VSS VSS nmos_lvt l=16n nfin=1
MN1_nr21 oh0[21] oh2[21] VSS VSS nmos_lvt l=16n nfin=1
MP0_nr22 VDD oh1[22] mid_nr22 VDD pmos_lvt l=16n nfin=1
MP1_nr22 mid_nr22 oh2[22] oh0[22] VDD pmos_lvt l=16n nfin=1
MN0_nr22 oh0[22] oh1[22] VSS VSS nmos_lvt l=16n nfin=1
MN1_nr22 oh0[22] oh2[22] VSS VSS nmos_lvt l=16n nfin=1
MP0_nr23 VDD oh1[23] mid_nr23 VDD pmos_lvt l=16n nfin=1
MP1_nr23 mid_nr23 oh2[23] oh0[23] VDD pmos_lvt l=16n nfin=1
MN0_nr23 oh0[23] oh1[23] VSS VSS nmos_lvt l=16n nfin=1
MN1_nr23 oh0[23] oh2[23] VSS VSS nmos_lvt l=16n nfin=1
MP0_nr24 VDD oh1[24] mid_nr24 VDD pmos_lvt l=16n nfin=1
MP1_nr24 mid_nr24 oh2[24] oh0[24] VDD pmos_lvt l=16n nfin=1
MN0_nr24 oh0[24] oh1[24] VSS VSS nmos_lvt l=16n nfin=1
MN1_nr24 oh0[24] oh2[24] VSS VSS nmos_lvt l=16n nfin=1
MP0_nr25 VDD oh1[25] mid_nr25 VDD pmos_lvt l=16n nfin=1
MP1_nr25 mid_nr25 oh2[25] oh0[25] VDD pmos_lvt l=16n nfin=1
MN0_nr25 oh0[25] oh1[25] VSS VSS nmos_lvt l=16n nfin=1
MN1_nr25 oh0[25] oh2[25] VSS VSS nmos_lvt l=16n nfin=1
MP0_nr26 VDD oh1[26] mid_nr26 VDD pmos_lvt l=16n nfin=1
MP1_nr26 mid_nr26 oh2[26] oh0[26] VDD pmos_lvt l=16n nfin=1
MN0_nr26 oh0[26] oh1[26] VSS VSS nmos_lvt l=16n nfin=1
MN1_nr26 oh0[26] oh2[26] VSS VSS nmos_lvt l=16n nfin=1
MP0_nr27 VDD oh1[27] mid_nr27 VDD pmos_lvt l=16n nfin=1
MP1_nr27 mid_nr27 oh2[27] oh0[27] VDD pmos_lvt l=16n nfin=1
MN0_nr27 oh0[27] oh1[27] VSS VSS nmos_lvt l=16n nfin=1
MN1_nr27 oh0[27] oh2[27] VSS VSS nmos_lvt l=16n nfin=1
MP0_nr28 VDD oh1[28] mid_nr28 VDD pmos_lvt l=16n nfin=1
MP1_nr28 mid_nr28 oh2[28] oh0[28] VDD pmos_lvt l=16n nfin=1
MN0_nr28 oh0[28] oh1[28] VSS VSS nmos_lvt l=16n nfin=1
MN1_nr28 oh0[28] oh2[28] VSS VSS nmos_lvt l=16n nfin=1
MP0_nr29 VDD oh1[29] mid_nr29 VDD pmos_lvt l=16n nfin=1
MP1_nr29 mid_nr29 oh2[29] oh0[29] VDD pmos_lvt l=16n nfin=1
MN0_nr29 oh0[29] oh1[29] VSS VSS nmos_lvt l=16n nfin=1
MN1_nr29 oh0[29] oh2[29] VSS VSS nmos_lvt l=16n nfin=1
MP0_nr30 VDD oh1[30] mid_nr30 VDD pmos_lvt l=16n nfin=1
MP1_nr30 mid_nr30 oh2[30] oh0[30] VDD pmos_lvt l=16n nfin=1
MN0_nr30 oh0[30] oh1[30] VSS VSS nmos_lvt l=16n nfin=1
MN1_nr30 oh0[30] oh2[30] VSS VSS nmos_lvt l=16n nfin=1
MP0_nr31 VDD oh1[31] mid_nr31 VDD pmos_lvt l=16n nfin=1
MP1_nr31 mid_nr31 oh2[31] oh0[31] VDD pmos_lvt l=16n nfin=1
MN0_nr31 oh0[31] oh1[31] VSS VSS nmos_lvt l=16n nfin=1
MN1_nr31 oh0[31] oh2[31] VSS VSS nmos_lvt l=16n nfin=1
MP0_buf0 mid2_buf0 oh0[28] VDD VDD pmos_lvt l=14n nfin=2
MN0_buf0 mid2_buf0 oh0[28] VSS VSS nmos_lvt l=14n nfin=2
MP1_buf0 hd[0] mid2_buf0 VDD VDD pmos_lvt l=14n nfin=2
MN1_buf0 hd[0] mid2_buf0 VSS VSS nmos_lvt l=14n nfin=2
MP0_buf1 mid2_buf1 oh1[24] VDD VDD pmos_lvt l=14n nfin=2
MN0_buf1 mid2_buf1 oh1[24] VSS VSS nmos_lvt l=14n nfin=2
MP1_buf1 hd[1] mid2_buf1 VDD VDD pmos_lvt l=14n nfin=2
MN1_buf1 hd[1] mid2_buf1 VSS VSS nmos_lvt l=14n nfin=2
MP0_buf2 mid2_buf2 oh2[20] VDD VDD pmos_lvt l=14n nfin=2
MN0_buf2 mid2_buf2 oh2[20] VSS VSS nmos_lvt l=14n nfin=2
MP1_buf2 hd[2] mid2_buf2 VDD VDD pmos_lvt l=14n nfin=2
MN1_buf2 hd[2] mid2_buf2 VSS VSS nmos_lvt l=14n nfin=2
MP0_buf3 mid2_buf3 oh0[16] VDD VDD pmos_lvt l=14n nfin=2
MN0_buf3 mid2_buf3 oh0[16] VSS VSS nmos_lvt l=14n nfin=2
MP1_buf3 hd[3] mid2_buf3 VDD VDD pmos_lvt l=14n nfin=2
MN1_buf3 hd[3] mid2_buf3 VSS VSS nmos_lvt l=14n nfin=2
MP0_buf4 mid2_buf4 oh1[12] VDD VDD pmos_lvt l=14n nfin=2
MN0_buf4 mid2_buf4 oh1[12] VSS VSS nmos_lvt l=14n nfin=2
MP1_buf4 hd[4] mid2_buf4 VDD VDD pmos_lvt l=14n nfin=2
MN1_buf4 hd[4] mid2_buf4 VSS VSS nmos_lvt l=14n nfin=2
MP0_buf5 mid2_buf5 oh2[8] VDD VDD pmos_lvt l=14n nfin=2
MN0_buf5 mid2_buf5 oh2[8] VSS VSS nmos_lvt l=14n nfin=2
MP1_buf5 hd[5] mid2_buf5 VDD VDD pmos_lvt l=14n nfin=2
MN1_buf5 hd[5] mid2_buf5 VSS VSS nmos_lvt l=14n nfin=2
MP0_buf6 mid2_buf6 oh0[31] VDD VDD pmos_lvt l=14n nfin=2
MN0_buf6 mid2_buf6 oh0[31] VSS VSS nmos_lvt l=14n nfin=2
MP1_buf6 hd[6] mid2_buf6 VDD VDD pmos_lvt l=14n nfin=2
MN1_buf6 hd[6] mid2_buf6 VSS VSS nmos_lvt l=14n nfin=2

* === WIRE RC PARASITICS (from OpenROAD routed DEF) ===
* Total: 1204 wire segments, 941 vias

Cwire1_A_0_ A[0] VSS 0.6506f
Cwire2_A_0_ A[0] VSS 0.6506f
Rwire_A_0_ A[0] A_0__rc 861.0
Cwire1_A_10_ A[10] VSS 0.3745f
Cwire2_A_10_ A[10] VSS 0.3745f
Rwire_A_10_ A[10] A_10__rc 204.9
Cwire1_A_11_ A[11] VSS 0.3511f
Cwire2_A_11_ A[11] VSS 0.3511f
Rwire_A_11_ A[11] A_11__rc 193.0
Cwire1_A_12_ A[12] VSS 0.3517f
Cwire2_A_12_ A[12] VSS 0.3517f
Rwire_A_12_ A[12] A_12__rc 413.0
Cwire1_A_13_ A[13] VSS 0.3631f
Cwire2_A_13_ A[13] VSS 0.3631f
Rwire_A_13_ A[13] A_13__rc 233.0
Cwire1_A_14_ A[14] VSS 0.4976f
Cwire2_A_14_ A[14] VSS 0.4976f
Rwire_A_14_ A[14] A_14__rc 348.8
Cwire1_A_15_ A[15] VSS 0.4390f
Cwire2_A_15_ A[15] VSS 0.4390f
Rwire_A_15_ A[15] A_15__rc 478.0
Cwire1_A_16_ A[16] VSS 0.3690f
Cwire2_A_16_ A[16] VSS 0.3690f
Rwire_A_16_ A[16] A_16__rc 617.8
Cwire1_A_17_ A[17] VSS 0.3021f
Cwire2_A_17_ A[17] VSS 0.3021f
Rwire_A_17_ A[17] A_17__rc 517.7
Cwire1_A_18_ A[18] VSS 0.4145f
Cwire2_A_18_ A[18] VSS 0.4145f
Rwire_A_18_ A[18] A_18__rc 481.2
Cwire1_A_19_ A[19] VSS 0.4646f
Cwire2_A_19_ A[19] VSS 0.4646f
Rwire_A_19_ A[19] A_19__rc 647.5
Cwire1_A_1_ A[1] VSS 0.3164f
Cwire2_A_1_ A[1] VSS 0.3164f
Rwire_A_1_ A[1] A_1__rc 370.3
Cwire1_A_20_ A[20] VSS 0.4221f
Cwire2_A_20_ A[20] VSS 0.4221f
Rwire_A_20_ A[20] A_20__rc 630.3
Cwire1_A_21_ A[21] VSS 0.2895f
Cwire2_A_21_ A[21] VSS 0.2895f
Rwire_A_21_ A[21] A_21__rc 361.7
Cwire1_A_22_ A[22] VSS 0.2789f
Cwire2_A_22_ A[22] VSS 0.2789f
Rwire_A_22_ A[22] A_22__rc 443.9
Cwire1_A_23_ A[23] VSS 0.1261f
Cwire2_A_23_ A[23] VSS 0.1261f
Rwire_A_23_ A[23] A_23__rc 194.5
Cwire1_A_24_ A[24] VSS 0.1225f
Cwire2_A_24_ A[24] VSS 0.1225f
Rwire_A_24_ A[24] A_24__rc 222.3
Cwire1_A_25_ A[25] VSS 0.0031f
Cwire2_A_25_ A[25] VSS 0.0031f
Rwire_A_25_ A[25] A_25__rc 15.2
Cwire1_A_26_ A[26] VSS 0.1088f
Cwire2_A_26_ A[26] VSS 0.1088f
Rwire_A_26_ A[26] A_26__rc 160.7
Cwire1_A_27_ A[27] VSS 0.2534f
Cwire2_A_27_ A[27] VSS 0.2534f
Rwire_A_27_ A[27] A_27__rc 344.8
Cwire1_A_28_ A[28] VSS 0.0406f
Cwire2_A_28_ A[28] VSS 0.0406f
Rwire_A_28_ A[28] A_28__rc 85.9
Cwire1_A_29_ A[29] VSS 0.0417f
Cwire2_A_29_ A[29] VSS 0.0417f
Rwire_A_29_ A[29] A_29__rc 94.7
Cwire1_A_2_ A[2] VSS 0.2304f
Cwire2_A_2_ A[2] VSS 0.2304f
Rwire_A_2_ A[2] A_2__rc 320.8
Cwire1_A_30_ A[30] VSS 0.0761f
Cwire2_A_30_ A[30] VSS 0.0761f
Rwire_A_30_ A[30] A_30__rc 135.8
Cwire1_A_31_ A[31] VSS 0.0768f
Cwire2_A_31_ A[31] VSS 0.0768f
Rwire_A_31_ A[31] A_31__rc 138.0
Cwire1_A_32_ A[32] VSS 0.0828f
Cwire2_A_32_ A[32] VSS 0.0828f
Rwire_A_32_ A[32] A_32__rc 148.7
Cwire1_A_33_ A[33] VSS 0.1362f
Cwire2_A_33_ A[33] VSS 0.1362f
Rwire_A_33_ A[33] A_33__rc 242.8
Cwire1_A_34_ A[34] VSS 0.0154f
Cwire2_A_34_ A[34] VSS 0.0154f
Rwire_A_34_ A[34] A_34__rc 43.9
Cwire1_A_35_ A[35] VSS 0.0588f
Cwire2_A_35_ A[35] VSS 0.0588f
Rwire_A_35_ A[35] A_35__rc 73.8
Cwire1_A_36_ A[36] VSS 0.0943f
Cwire2_A_36_ A[36] VSS 0.0943f
Rwire_A_36_ A[36] A_36__rc 95.2
Cwire1_A_37_ A[37] VSS 0.1181f
Cwire2_A_37_ A[37] VSS 0.1181f
Rwire_A_37_ A[37] A_37__rc 113.1
Cwire1_A_38_ A[38] VSS 0.3431f
Cwire2_A_38_ A[38] VSS 0.3431f
Rwire_A_38_ A[38] A_38__rc 511.9
Cwire1_A_39_ A[39] VSS 0.3245f
Cwire2_A_39_ A[39] VSS 0.3245f
Rwire_A_39_ A[39] A_39__rc 412.2
Cwire1_A_3_ A[3] VSS 0.1625f
Cwire2_A_3_ A[3] VSS 0.1625f
Rwire_A_3_ A[3] A_3__rc 227.9
Cwire1_A_40_ A[40] VSS 0.3527f
Cwire2_A_40_ A[40] VSS 0.3527f
Rwire_A_40_ A[40] A_40__rc 549.2
Cwire1_A_41_ A[41] VSS 0.2863f
Cwire2_A_41_ A[41] VSS 0.2863f
Rwire_A_41_ A[41] A_41__rc 353.0
Cwire1_A_42_ A[42] VSS 0.4629f
Cwire2_A_42_ A[42] VSS 0.4629f
Rwire_A_42_ A[42] A_42__rc 516.6
Cwire1_A_43_ A[43] VSS 0.3662f
Cwire2_A_43_ A[43] VSS 0.3662f
Rwire_A_43_ A[43] A_43__rc 438.6
Cwire1_A_44_ A[44] VSS 0.3802f
Cwire2_A_44_ A[44] VSS 0.3802f
Rwire_A_44_ A[44] A_44__rc 574.5
Cwire1_A_45_ A[45] VSS 0.3375f
Cwire2_A_45_ A[45] VSS 0.3375f
Rwire_A_45_ A[45] A_45__rc 561.6
Cwire1_A_46_ A[46] VSS 0.0352f
Cwire2_A_46_ A[46] VSS 0.0352f
Rwire_A_46_ A[46] A_46__rc 62.8
Cwire1_A_47_ A[47] VSS 0.0369f
Cwire2_A_47_ A[47] VSS 0.0369f
Rwire_A_47_ A[47] A_47__rc 58.5
Cwire1_A_48_ A[48] VSS 0.2327f
Cwire2_A_48_ A[48] VSS 0.2327f
Rwire_A_48_ A[48] A_48__rc 241.0
Cwire1_A_49_ A[49] VSS 0.2354f
Cwire2_A_49_ A[49] VSS 0.2354f
Rwire_A_49_ A[49] A_49__rc 240.6
Cwire1_A_4_ A[4] VSS 0.1635f
Cwire2_A_4_ A[4] VSS 0.1635f
Rwire_A_4_ A[4] A_4__rc 245.6
Cwire1_A_50_ A[50] VSS 0.2217f
Cwire2_A_50_ A[50] VSS 0.2217f
Rwire_A_50_ A[50] A_50__rc 381.8
Cwire1_A_51_ A[51] VSS 0.2167f
Cwire2_A_51_ A[51] VSS 0.2167f
Rwire_A_51_ A[51] A_51__rc 390.0
Cwire1_A_52_ A[52] VSS 0.3060f
Cwire2_A_52_ A[52] VSS 0.3060f
Rwire_A_52_ A[52] A_52__rc 495.0
Cwire1_A_53_ A[53] VSS 0.2280f
Cwire2_A_53_ A[53] VSS 0.2280f
Rwire_A_53_ A[53] A_53__rc 396.9
Cwire1_A_54_ A[54] VSS 0.2318f
Cwire2_A_54_ A[54] VSS 0.2318f
Rwire_A_54_ A[54] A_54__rc 228.6
Cwire1_A_55_ A[55] VSS 0.2493f
Cwire2_A_55_ A[55] VSS 0.2493f
Rwire_A_55_ A[55] A_55__rc 253.0
Cwire1_A_56_ A[56] VSS 0.2214f
Cwire2_A_56_ A[56] VSS 0.2214f
Rwire_A_56_ A[56] A_56__rc 224.5
Cwire1_A_57_ A[57] VSS 0.2241f
Cwire2_A_57_ A[57] VSS 0.2241f
Rwire_A_57_ A[57] A_57__rc 221.7
Cwire1_A_58_ A[58] VSS 0.1490f
Cwire2_A_58_ A[58] VSS 0.1490f
Rwire_A_58_ A[58] A_58__rc 166.2
Cwire1_A_59_ A[59] VSS 0.1505f
Cwire2_A_59_ A[59] VSS 0.1505f
Rwire_A_59_ A[59] A_59__rc 158.4
Cwire1_A_5_ A[5] VSS 0.1011f
Cwire2_A_5_ A[5] VSS 0.1011f
Rwire_A_5_ A[5] A_5__rc 122.4
Cwire1_A_60_ A[60] VSS 0.0426f
Cwire2_A_60_ A[60] VSS 0.0426f
Rwire_A_60_ A[60] A_60__rc 78.7
Cwire1_A_61_ A[61] VSS 0.0443f
Cwire2_A_61_ A[61] VSS 0.0443f
Rwire_A_61_ A[61] A_61__rc 74.4
Cwire1_A_62_ A[62] VSS 0.2270f
Cwire2_A_62_ A[62] VSS 0.2270f
Rwire_A_62_ A[62] A_62__rc 230.1
Cwire1_A_63_ A[63] VSS 0.2438f
Cwire2_A_63_ A[63] VSS 0.2438f
Rwire_A_63_ A[63] A_63__rc 251.0
Cwire1_A_6_ A[6] VSS 0.0352f
Cwire2_A_6_ A[6] VSS 0.0352f
Rwire_A_6_ A[6] A_6__rc 62.8
Cwire1_A_7_ A[7] VSS 0.0369f
Cwire2_A_7_ A[7] VSS 0.0369f
Rwire_A_7_ A[7] A_7__rc 58.5
Cwire1_A_8_ A[8] VSS 0.1552f
Cwire2_A_8_ A[8] VSS 0.1552f
Rwire_A_8_ A[8] A_8__rc 191.8
Cwire1_A_9_ A[9] VSS 0.1721f
Cwire2_A_9_ A[9] VSS 0.1721f
Rwire_A_9_ A[9] A_9__rc 192.9
Cwire1_B_0_ B[0] VSS 0.0246f
Cwire2_B_0_ B[0] VSS 0.0246f
Rwire_B_0_ B[0] B_0__rc 45.0
Cwire1_B_10_ B[10] VSS 0.1952f
Cwire2_B_10_ B[10] VSS 0.1952f
Rwire_B_10_ B[10] B_10__rc 300.3
Cwire1_B_11_ B[11] VSS 0.2191f
Cwire2_B_11_ B[11] VSS 0.2191f
Rwire_B_11_ B[11] B_11__rc 315.1
Cwire1_B_12_ B[12] VSS 0.2996f
Cwire2_B_12_ B[12] VSS 0.2996f
Rwire_B_12_ B[12] B_12__rc 454.6
Cwire1_B_13_ B[13] VSS 0.2125f
Cwire2_B_13_ B[13] VSS 0.2125f
Rwire_B_13_ B[13] B_13__rc 345.2
Cwire1_B_14_ B[14] VSS 0.1713f
Cwire2_B_14_ B[14] VSS 0.1713f
Rwire_B_14_ B[14] B_14__rc 295.9
Cwire1_B_15_ B[15] VSS 0.2151f
Cwire2_B_15_ B[15] VSS 0.2151f
Rwire_B_15_ B[15] B_15__rc 361.5
Cwire1_B_16_ B[16] VSS 0.2332f
Cwire2_B_16_ B[16] VSS 0.2332f
Rwire_B_16_ B[16] B_16__rc 235.6
Cwire1_B_17_ B[17] VSS 0.2417f
Cwire2_B_17_ B[17] VSS 0.2417f
Rwire_B_17_ B[17] B_17__rc 240.4
Cwire1_B_18_ B[18] VSS 0.0665f
Cwire2_B_18_ B[18] VSS 0.0665f
Rwire_B_18_ B[18] B_18__rc 136.1
Cwire1_B_19_ B[19] VSS 0.0926f
Cwire2_B_19_ B[19] VSS 0.0926f
Rwire_B_19_ B[19] B_19__rc 147.7
Cwire1_B_1_ B[1] VSS 0.1252f
Cwire2_B_1_ B[1] VSS 0.1252f
Rwire_B_1_ B[1] B_1__rc 199.8
Cwire1_B_20_ B[20] VSS 0.1461f
Cwire2_B_20_ B[20] VSS 0.1461f
Rwire_B_20_ B[20] B_20__rc 253.5
Cwire1_B_21_ B[21] VSS 0.1322f
Cwire2_B_21_ B[21] VSS 0.1322f
Rwire_B_21_ B[21] B_21__rc 217.3
Cwire1_B_22_ B[22] VSS 0.2163f
Cwire2_B_22_ B[22] VSS 0.2163f
Rwire_B_22_ B[22] B_22__rc 343.1
Cwire1_B_23_ B[23] VSS 0.2291f
Cwire2_B_23_ B[23] VSS 0.2291f
Rwire_B_23_ B[23] B_23__rc 314.0
Cwire1_B_24_ B[24] VSS 0.2195f
Cwire2_B_24_ B[24] VSS 0.2195f
Rwire_B_24_ B[24] B_24__rc 327.3
Cwire1_B_25_ B[25] VSS 0.1952f
Cwire2_B_25_ B[25] VSS 0.1952f
Rwire_B_25_ B[25] B_25__rc 261.3
Cwire1_B_26_ B[26] VSS 0.1041f
Cwire2_B_26_ B[26] VSS 0.1041f
Rwire_B_26_ B[26] B_26__rc 175.1
Cwire1_B_27_ B[27] VSS 0.1133f
Cwire2_B_27_ B[27] VSS 0.1133f
Rwire_B_27_ B[27] B_27__rc 159.3
Cwire1_B_28_ B[28] VSS 0.2919f
Cwire2_B_28_ B[28] VSS 0.2919f
Rwire_B_28_ B[28] B_28__rc 389.4
Cwire1_B_29_ B[29] VSS 0.3808f
Cwire2_B_29_ B[29] VSS 0.3808f
Rwire_B_29_ B[29] B_29__rc 655.6
Cwire1_B_2_ B[2] VSS 0.2014f
Cwire2_B_2_ B[2] VSS 0.2014f
Rwire_B_2_ B[2] B_2__rc 304.8
Cwire1_B_30_ B[30] VSS 0.3043f
Cwire2_B_30_ B[30] VSS 0.3043f
Rwire_B_30_ B[30] B_30__rc 509.0
Cwire1_B_31_ B[31] VSS 0.2592f
Cwire2_B_31_ B[31] VSS 0.2592f
Rwire_B_31_ B[31] B_31__rc 380.8
Cwire1_B_32_ B[32] VSS 0.2357f
Cwire2_B_32_ B[32] VSS 0.2357f
Rwire_B_32_ B[32] B_32__rc 368.7
Cwire1_B_33_ B[33] VSS 0.3040f
Cwire2_B_33_ B[33] VSS 0.3040f
Rwire_B_33_ B[33] B_33__rc 516.7
Cwire1_B_34_ B[34] VSS 0.2847f
Cwire2_B_34_ B[34] VSS 0.2847f
Rwire_B_34_ B[34] B_34__rc 384.6
Cwire1_B_35_ B[35] VSS 0.2888f
Cwire2_B_35_ B[35] VSS 0.2888f
Rwire_B_35_ B[35] B_35__rc 396.3
Cwire1_B_36_ B[36] VSS 0.3813f
Cwire2_B_36_ B[36] VSS 0.3813f
Rwire_B_36_ B[36] B_36__rc 660.8
Cwire1_B_37_ B[37] VSS 0.2808f
Cwire2_B_37_ B[37] VSS 0.2808f
Rwire_B_37_ B[37] B_37__rc 407.3
Cwire1_B_38_ B[38] VSS 0.0581f
Cwire2_B_38_ B[38] VSS 0.0581f
Rwire_B_38_ B[38] B_38__rc 83.5
Cwire1_B_39_ B[39] VSS 0.0490f
Cwire2_B_39_ B[39] VSS 0.0490f
Rwire_B_39_ B[39] B_39__rc 95.1
Cwire1_B_3_ B[3] VSS 0.2814f
Cwire2_B_3_ B[3] VSS 0.2814f
Rwire_B_3_ B[3] B_3__rc 435.5
Cwire1_B_40_ B[40] VSS 0.1864f
Cwire2_B_40_ B[40] VSS 0.1864f
Rwire_B_40_ B[40] B_40__rc 313.9
Cwire1_B_41_ B[41] VSS 0.1781f
Cwire2_B_41_ B[41] VSS 0.1781f
Rwire_B_41_ B[41] B_41__rc 308.0
Cwire1_B_42_ B[42] VSS 0.0556f
Cwire2_B_42_ B[42] VSS 0.0556f
Rwire_B_42_ B[42] B_42__rc 102.7
Cwire1_B_43_ B[43] VSS 0.0513f
Cwire2_B_43_ B[43] VSS 0.0513f
Rwire_B_43_ B[43] B_43__rc 95.5
Cwire1_B_44_ B[44] VSS 0.2678f
Cwire2_B_44_ B[44] VSS 0.2678f
Rwire_B_44_ B[44] B_44__rc 138.2
Cwire1_B_45_ B[45] VSS 0.2632f
Cwire2_B_45_ B[45] VSS 0.2632f
Rwire_B_45_ B[45] B_45__rc 142.1
Cwire1_B_46_ B[46] VSS 0.5140f
Cwire2_B_46_ B[46] VSS 0.5140f
Rwire_B_46_ B[46] B_46__rc 748.8
Cwire1_B_47_ B[47] VSS 0.4591f
Cwire2_B_47_ B[47] VSS 0.4591f
Rwire_B_47_ B[47] B_47__rc 534.4
Cwire1_B_48_ B[48] VSS 0.3417f
Cwire2_B_48_ B[48] VSS 0.3417f
Rwire_B_48_ B[48] B_48__rc 586.5
Cwire1_B_49_ B[49] VSS 0.3393f
Cwire2_B_49_ B[49] VSS 0.3393f
Rwire_B_49_ B[49] B_49__rc 596.7
Cwire1_B_4_ B[4] VSS 0.3880f
Cwire2_B_4_ B[4] VSS 0.3880f
Rwire_B_4_ B[4] B_4__rc 537.3
Cwire1_B_50_ B[50] VSS 0.3631f
Cwire2_B_50_ B[50] VSS 0.3631f
Rwire_B_50_ B[50] B_50__rc 350.1
Cwire1_B_51_ B[51] VSS 0.4355f
Cwire2_B_51_ B[51] VSS 0.4355f
Rwire_B_51_ B[51] B_51__rc 392.2
Cwire1_B_52_ B[52] VSS 0.3738f
Cwire2_B_52_ B[52] VSS 0.3738f
Rwire_B_52_ B[52] B_52__rc 210.3
Cwire1_B_53_ B[53] VSS 0.3608f
Cwire2_B_53_ B[53] VSS 0.3608f
Rwire_B_53_ B[53] B_53__rc 209.2
Cwire1_B_54_ B[54] VSS 0.4399f
Cwire2_B_54_ B[54] VSS 0.4399f
Rwire_B_54_ B[54] B_54__rc 681.5
Cwire1_B_55_ B[55] VSS 0.0069f
Cwire2_B_55_ B[55] VSS 0.0069f
Rwire_B_55_ B[55] B_55__rc 31.5
Cwire1_B_56_ B[56] VSS 0.0981f
Cwire2_B_56_ B[56] VSS 0.0981f
Rwire_B_56_ B[56] B_56__rc 89.8
Cwire1_B_57_ B[57] VSS 0.0340f
Cwire2_B_57_ B[57] VSS 0.0340f
Rwire_B_57_ B[57] B_57__rc 76.7
Cwire1_B_58_ B[58] VSS 0.2329f
Cwire2_B_58_ B[58] VSS 0.2329f
Rwire_B_58_ B[58] B_58__rc 293.6
Cwire1_B_59_ B[59] VSS 0.2062f
Cwire2_B_59_ B[59] VSS 0.2062f
Rwire_B_59_ B[59] B_59__rc 190.5
Cwire1_B_5_ B[5] VSS 0.1200f
Cwire2_B_5_ B[5] VSS 0.1200f
Rwire_B_5_ B[5] B_5__rc 136.2
Cwire1_B_60_ B[60] VSS 0.3863f
Cwire2_B_60_ B[60] VSS 0.3863f
Rwire_B_60_ B[60] B_60__rc 438.3
Cwire1_B_61_ B[61] VSS 0.2580f
Cwire2_B_61_ B[61] VSS 0.2580f
Rwire_B_61_ B[61] B_61__rc 257.5
Cwire1_B_62_ B[62] VSS 0.0919f
Cwire2_B_62_ B[62] VSS 0.0919f
Rwire_B_62_ B[62] B_62__rc 140.1
Cwire1_B_63_ B[63] VSS 0.0829f
Cwire2_B_63_ B[63] VSS 0.0829f
Rwire_B_63_ B[63] B_63__rc 116.8
Cwire1_B_6_ B[6] VSS 0.3921f
Cwire2_B_6_ B[6] VSS 0.3921f
Rwire_B_6_ B[6] B_6__rc 355.5
Cwire1_B_7_ B[7] VSS 0.3536f
Cwire2_B_7_ B[7] VSS 0.3536f
Rwire_B_7_ B[7] B_7__rc 376.5
Cwire1_B_8_ B[8] VSS 0.1100f
Cwire2_B_8_ B[8] VSS 0.1100f
Rwire_B_8_ B[8] B_8__rc 88.0
Cwire1_B_9_ B[9] VSS 0.3147f
Cwire2_B_9_ B[9] VSS 0.3147f
Rwire_B_9_ B[9] B_9__rc 255.6
Cwire1_hd_0_ hd[0] VSS 0.0227f
Cwire2_hd_0_ hd[0] VSS 0.0227f
Rwire_hd_0_ hd[0] hd_0__rc 47.8
Cwire1_hd_1_ hd[1] VSS 0.0151f
Cwire2_hd_1_ hd[1] VSS 0.0151f
Rwire_hd_1_ hd[1] hd_1__rc 35.2
Cwire1_hd_2_ hd[2] VSS 0.0128f
Cwire2_hd_2_ hd[2] VSS 0.0128f
Rwire_hd_2_ hd[2] hd_2__rc 31.4
Cwire1_hd_3_ hd[3] VSS 0.0312f
Cwire2_hd_3_ hd[3] VSS 0.0312f
Rwire_hd_3_ hd[3] hd_3__rc 72.6
Cwire1_hd_4_ hd[4] VSS 0.0204f
Cwire2_hd_4_ hd[4] VSS 0.0204f
Rwire_hd_4_ hd[4] hd_4__rc 44.0
Cwire1_hd_5_ hd[5] VSS 0.0076f
Cwire2_hd_5_ hd[5] VSS 0.0076f
Rwire_hd_5_ hd[5] hd_5__rc 22.6
Cwire1_hd_6_ hd[6] VSS 0.0204f
Cwire2_hd_6_ hd[6] VSS 0.0204f
Rwire_hd_6_ hd[6] hd_6__rc 44.0
Cwire1_noh1_0_ noh1[0] VSS 0.0697f
Cwire2_noh1_0_ noh1[0] VSS 0.0697f
Rwire_noh1_0_ noh1[0] noh1_0__rc 117.2
Cwire1_noh1_10_ noh1[10] VSS 0.0242f
Cwire2_noh1_10_ noh1[10] VSS 0.0242f
Rwire_noh1_10_ noh1[10] noh1_10__rc 60.3
Cwire1_noh1_11_ noh1[11] VSS 0.0464f
Cwire2_noh1_11_ noh1[11] VSS 0.0464f
Rwire_noh1_11_ noh1[11] noh1_11__rc 97.4
Cwire1_noh1_12_ noh1[12] VSS 0.0273f
Cwire2_noh1_12_ noh1[12] VSS 0.0273f
Rwire_noh1_12_ noh1[12] noh1_12__rc 90.5
Cwire1_noh1_13_ noh1[13] VSS 0.0704f
Cwire2_noh1_13_ noh1[13] VSS 0.0704f
Rwire_noh1_13_ noh1[13] noh1_13__rc 130.2
Cwire1_noh1_14_ noh1[14] VSS 0.0684f
Cwire2_noh1_14_ noh1[14] VSS 0.0684f
Rwire_noh1_14_ noh1[14] noh1_14__rc 113.1
Cwire1_noh1_15_ noh1[15] VSS 0.0189f
Cwire2_noh1_15_ noh1[15] VSS 0.0189f
Rwire_noh1_15_ noh1[15] noh1_15__rc 51.5
Cwire1_noh1_16_ noh1[16] VSS 0.0463f
Cwire2_noh1_16_ noh1[16] VSS 0.0463f
Rwire_noh1_16_ noh1[16] noh1_16__rc 79.3
Cwire1_noh1_17_ noh1[17] VSS 0.0832f
Cwire2_noh1_17_ noh1[17] VSS 0.0832f
Rwire_noh1_17_ noh1[17] noh1_17__rc 95.1
Cwire1_noh1_18_ noh1[18] VSS 0.0442f
Cwire2_noh1_18_ noh1[18] VSS 0.0442f
Rwire_noh1_18_ noh1[18] noh1_18__rc 97.2
Cwire1_noh1_19_ noh1[19] VSS 0.0653f
Cwire2_noh1_19_ noh1[19] VSS 0.0653f
Rwire_noh1_19_ noh1[19] noh1_19__rc 128.9
Cwire1_noh1_1_ noh1[1] VSS 0.0243f
Cwire2_noh1_1_ noh1[1] VSS 0.0243f
Rwire_noh1_1_ noh1[1] noh1_1__rc 60.5
Cwire1_noh1_20_ noh1[20] VSS 0.0283f
Cwire2_noh1_20_ noh1[20] VSS 0.0283f
Rwire_noh1_20_ noh1[20] noh1_20__rc 78.5
Cwire1_noh1_21_ noh1[21] VSS 0.0211f
Cwire2_noh1_21_ noh1[21] VSS 0.0211f
Rwire_noh1_21_ noh1[21] noh1_21__rc 55.1
Cwire1_noh1_22_ noh1[22] VSS 0.0668f
Cwire2_noh1_22_ noh1[22] VSS 0.0668f
Rwire_noh1_22_ noh1[22] noh1_22__rc 116.5
Cwire1_noh1_23_ noh1[23] VSS 0.0189f
Cwire2_noh1_23_ noh1[23] VSS 0.0189f
Rwire_noh1_23_ noh1[23] noh1_23__rc 51.5
Cwire1_noh1_24_ noh1[24] VSS 0.0190f
Cwire2_noh1_24_ noh1[24] VSS 0.0190f
Rwire_noh1_24_ noh1[24] noh1_24__rc 51.7
Cwire1_noh1_25_ noh1[25] VSS 0.0655f
Cwire2_noh1_25_ noh1[25] VSS 0.0655f
Rwire_noh1_25_ noh1[25] noh1_25__rc 92.6
Cwire1_noh1_26_ noh1[26] VSS 0.0435f
Cwire2_noh1_26_ noh1[26] VSS 0.0435f
Rwire_noh1_26_ noh1[26] noh1_26__rc 92.5
Cwire1_noh1_27_ noh1[27] VSS 0.0480f
Cwire2_noh1_27_ noh1[27] VSS 0.0480f
Rwire_noh1_27_ noh1[27] noh1_27__rc 79.8
Cwire1_noh1_28_ noh1[28] VSS 0.0227f
Cwire2_noh1_28_ noh1[28] VSS 0.0227f
Rwire_noh1_28_ noh1[28] noh1_28__rc 57.8
Cwire1_noh1_29_ noh1[29] VSS 0.0284f
Cwire2_noh1_29_ noh1[29] VSS 0.0284f
Rwire_noh1_29_ noh1[29] noh1_29__rc 67.2
Cwire1_noh1_2_ noh1[2] VSS 0.0246f
Cwire2_noh1_2_ noh1[2] VSS 0.0246f
Rwire_noh1_2_ noh1[2] noh1_2__rc 61.0
Cwire1_noh1_30_ noh1[30] VSS 0.0328f
Cwire2_noh1_30_ noh1[30] VSS 0.0328f
Rwire_noh1_30_ noh1[30] noh1_30__rc 97.1
Cwire1_noh1_31_ noh1[31] VSS 0.0281f
Cwire2_noh1_31_ noh1[31] VSS 0.0281f
Rwire_noh1_31_ noh1[31] noh1_31__rc 66.8
Cwire1_noh1_3_ noh1[3] VSS 0.0849f
Cwire2_noh1_3_ noh1[3] VSS 0.0849f
Rwire_noh1_3_ noh1[3] noh1_3__rc 154.5
Cwire1_noh1_4_ noh1[4] VSS 0.0284f
Cwire2_noh1_4_ noh1[4] VSS 0.0284f
Rwire_noh1_4_ noh1[4] noh1_4__rc 67.2
Cwire1_noh1_5_ noh1[5] VSS 0.0393f
Cwire2_noh1_5_ noh1[5] VSS 0.0393f
Rwire_noh1_5_ noh1[5] noh1_5__rc 91.3
Cwire1_noh1_6_ noh1[6] VSS 0.0781f
Cwire2_noh1_6_ noh1[6] VSS 0.0781f
Rwire_noh1_6_ noh1[6] noh1_6__rc 135.4
Cwire1_noh1_7_ noh1[7] VSS 0.0243f
Cwire2_noh1_7_ noh1[7] VSS 0.0243f
Rwire_noh1_7_ noh1[7] noh1_7__rc 60.5
Cwire1_noh1_8_ noh1[8] VSS 0.0605f
Cwire2_noh1_8_ noh1[8] VSS 0.0605f
Rwire_noh1_8_ noh1[8] noh1_8__rc 120.8
Cwire1_noh1_9_ noh1[9] VSS 0.0520f
Cwire2_noh1_9_ noh1[9] VSS 0.0520f
Rwire_noh1_9_ noh1[9] noh1_9__rc 88.8
Cwire1_noh2_0_ noh2[0] VSS 0.0139f
Cwire2_noh2_0_ noh2[0] VSS 0.0139f
Rwire_noh2_0_ noh2[0] noh2_0__rc 43.2
Cwire1_noh2_10_ noh2[10] VSS 0.0207f
Cwire2_noh2_10_ noh2[10] VSS 0.0207f
Rwire_noh2_10_ noh2[10] noh2_10__rc 54.4
Cwire1_noh2_11_ noh2[11] VSS 0.0790f
Cwire2_noh2_11_ noh2[11] VSS 0.0790f
Rwire_noh2_11_ noh2[11] noh2_11__rc 149.0
Cwire1_noh2_12_ noh2[12] VSS 0.0155f
Cwire2_noh2_12_ noh2[12] VSS 0.0155f
Rwire_noh2_12_ noh2[12] noh2_12__rc 77.8
Cwire1_noh2_13_ noh2[13] VSS 0.0216f
Cwire2_noh2_13_ noh2[13] VSS 0.0216f
Rwire_noh2_13_ noh2[13] noh2_13__rc 56.0
Cwire1_noh2_14_ noh2[14] VSS 0.0524f
Cwire2_noh2_14_ noh2[14] VSS 0.0524f
Rwire_noh2_14_ noh2[14] noh2_14__rc 100.2
Cwire1_noh2_15_ noh2[15] VSS 0.0132f
Cwire2_noh2_15_ noh2[15] VSS 0.0132f
Rwire_noh2_15_ noh2[15] noh2_15__rc 42.0
Cwire1_noh2_16_ noh2[16] VSS 0.0238f
Cwire2_noh2_16_ noh2[16] VSS 0.0238f
Rwire_noh2_16_ noh2[16] noh2_16__rc 59.6
Cwire1_noh2_17_ noh2[17] VSS 0.0671f
Cwire2_noh2_17_ noh2[17] VSS 0.0671f
Rwire_noh2_17_ noh2[17] noh2_17__rc 123.4
Cwire1_noh2_18_ noh2[18] VSS 0.0298f
Cwire2_noh2_18_ noh2[18] VSS 0.0298f
Rwire_noh2_18_ noh2[18] noh2_18__rc 75.5
Cwire1_noh2_19_ noh2[19] VSS 0.0529f
Cwire2_noh2_19_ noh2[19] VSS 0.0529f
Rwire_noh2_19_ noh2[19] noh2_19__rc 108.2
Cwire1_noh2_1_ noh2[1] VSS 0.0246f
Cwire2_noh2_1_ noh2[1] VSS 0.0246f
Rwire_noh2_1_ noh2[1] noh2_1__rc 61.0
Cwire1_noh2_20_ noh2[20] VSS 0.0151f
Cwire2_noh2_20_ noh2[20] VSS 0.0151f
Rwire_noh2_20_ noh2[20] noh2_20__rc 45.2
Cwire1_noh2_21_ noh2[21] VSS 0.0139f
Cwire2_noh2_21_ noh2[21] VSS 0.0139f
Rwire_noh2_21_ noh2[21] noh2_21__rc 43.2
Cwire1_noh2_22_ noh2[22] VSS 0.0545f
Cwire2_noh2_22_ noh2[22] VSS 0.0545f
Rwire_noh2_22_ noh2[22] noh2_22__rc 113.0
Cwire1_noh2_23_ noh2[23] VSS 0.0132f
Cwire2_noh2_23_ noh2[23] VSS 0.0132f
Rwire_noh2_23_ noh2[23] noh2_23__rc 42.0
Cwire1_noh2_24_ noh2[24] VSS 0.0454f
Cwire2_noh2_24_ noh2[24] VSS 0.0454f
Rwire_noh2_24_ noh2[24] noh2_24__rc 95.6
Cwire1_noh2_25_ noh2[25] VSS 0.0139f
Cwire2_noh2_25_ noh2[25] VSS 0.0139f
Rwire_noh2_25_ noh2[25] noh2_25__rc 43.2
Cwire1_noh2_26_ noh2[26] VSS 0.0246f
Cwire2_noh2_26_ noh2[26] VSS 0.0246f
Rwire_noh2_26_ noh2[26] noh2_26__rc 61.0
Cwire1_noh2_27_ noh2[27] VSS 0.0594f
Cwire2_noh2_27_ noh2[27] VSS 0.0594f
Rwire_noh2_27_ noh2[27] noh2_27__rc 109.2
Cwire1_noh2_28_ noh2[28] VSS 0.0151f
Cwire2_noh2_28_ noh2[28] VSS 0.0151f
Rwire_noh2_28_ noh2[28] noh2_28__rc 45.2
Cwire1_noh2_29_ noh2[29] VSS 0.0151f
Cwire2_noh2_29_ noh2[29] VSS 0.0151f
Rwire_noh2_29_ noh2[29] noh2_29__rc 45.2
Cwire1_noh2_2_ noh2[2] VSS 0.0298f
Cwire2_noh2_2_ noh2[2] VSS 0.0298f
Rwire_noh2_2_ noh2[2] noh2_2__rc 75.5
Cwire1_noh2_30_ noh2[30] VSS 0.0486f
Cwire2_noh2_30_ noh2[30] VSS 0.0486f
Rwire_noh2_30_ noh2[30] noh2_30__rc 101.0
Cwire1_noh2_31_ noh2[31] VSS 0.0599f
Cwire2_noh2_31_ noh2[31] VSS 0.0599f
Rwire_noh2_31_ noh2[31] noh2_31__rc 91.0
Cwire1_noh2_3_ noh2[3] VSS 0.0754f
Cwire2_noh2_3_ noh2[3] VSS 0.0754f
Rwire_noh2_3_ noh2[3] noh2_3__rc 133.1
Cwire1_noh2_4_ noh2[4] VSS 0.0151f
Cwire2_noh2_4_ noh2[4] VSS 0.0151f
Rwire_noh2_4_ noh2[4] noh2_4__rc 45.2
Cwire1_noh2_5_ noh2[5] VSS 0.0139f
Cwire2_noh2_5_ noh2[5] VSS 0.0139f
Rwire_noh2_5_ noh2[5] noh2_5__rc 43.2
Cwire1_noh2_6_ noh2[6] VSS 0.0396f
Cwire2_noh2_6_ noh2[6] VSS 0.0396f
Rwire_noh2_6_ noh2[6] noh2_6__rc 77.4
Cwire1_noh2_7_ noh2[7] VSS 0.0139f
Cwire2_noh2_7_ noh2[7] VSS 0.0139f
Rwire_noh2_7_ noh2[7] noh2_7__rc 43.2
Cwire1_noh2_8_ noh2[8] VSS 0.0227f
Cwire2_noh2_8_ noh2[8] VSS 0.0227f
Rwire_noh2_8_ noh2[8] noh2_8__rc 57.8
Cwire1_noh2_9_ noh2[9] VSS 0.0139f
Cwire2_noh2_9_ noh2[9] VSS 0.0139f
Rwire_noh2_9_ noh2[9] noh2_9__rc 43.2
Cwire1_oh0_16_ oh0[16] VSS 0.0900f
Cwire2_oh0_16_ oh0[16] VSS 0.0900f
Rwire_oh0_16_ oh0[16] oh0_16__rc 123.3
Cwire1_oh0_28_ oh0[28] VSS 0.0473f
Cwire2_oh0_28_ oh0[28] VSS 0.0473f
Rwire_oh0_28_ oh0[28] oh0_28__rc 88.8
Cwire1_oh0_31_ oh0[31] VSS 0.0170f
Cwire2_oh0_31_ oh0[31] VSS 0.0170f
Rwire_oh0_31_ oh0[31] oh0_31__rc 38.4
Cwire1_oh1_0_ oh1[0] VSS 0.0194f
Cwire2_oh1_0_ oh1[0] VSS 0.0194f
Rwire_oh1_0_ oh1[0] oh1_0__rc 58.2
Cwire1_oh1_10_ oh1[10] VSS 0.0585f
Cwire2_oh1_10_ oh1[10] VSS 0.0585f
Rwire_oh1_10_ oh1[10] oh1_10__rc 130.4
Cwire1_oh1_11_ oh1[11] VSS 0.0720f
Cwire2_oh1_11_ oh1[11] VSS 0.0720f
Rwire_oh1_11_ oh1[11] oh1_11__rc 116.7
Cwire1_oh1_12_ oh1[12] VSS 0.0566f
Cwire2_oh1_12_ oh1[12] VSS 0.0566f
Rwire_oh1_12_ oh1[12] oh1_12__rc 118.9
Cwire1_oh1_13_ oh1[13] VSS 0.0085f
Cwire2_oh1_13_ oh1[13] VSS 0.0085f
Rwire_oh1_13_ oh1[13] oh1_13__rc 34.2
Cwire1_oh1_14_ oh1[14] VSS 0.0793f
Cwire2_oh1_14_ oh1[14] VSS 0.0793f
Rwire_oh1_14_ oh1[14] oh1_14__rc 121.4
Cwire1_oh1_15_ oh1[15] VSS 0.0100f
Cwire2_oh1_15_ oh1[15] VSS 0.0100f
Rwire_oh1_15_ oh1[15] oh1_15__rc 36.6
Cwire1_oh1_16_ oh1[16] VSS 0.0100f
Cwire2_oh1_16_ oh1[16] VSS 0.0100f
Rwire_oh1_16_ oh1[16] oh1_16__rc 36.6
Cwire1_oh1_17_ oh1[17] VSS 0.0343f
Cwire2_oh1_17_ oh1[17] VSS 0.0343f
Rwire_oh1_17_ oh1[17] oh1_17__rc 77.2
Cwire1_oh1_18_ oh1[18] VSS 0.0818f
Cwire2_oh1_18_ oh1[18] VSS 0.0818f
Rwire_oh1_18_ oh1[18] oh1_18__rc 156.3
Cwire1_oh1_19_ oh1[19] VSS 0.0327f
Cwire2_oh1_19_ oh1[19] VSS 0.0327f
Rwire_oh1_19_ oh1[19] oh1_19__rc 74.5
Cwire1_oh1_1_ oh1[1] VSS 0.0104f
Cwire2_oh1_1_ oh1[1] VSS 0.0104f
Rwire_oh1_1_ oh1[1] oh1_1__rc 37.3
Cwire1_oh1_20_ oh1[20] VSS 0.0133f
Cwire2_oh1_20_ oh1[20] VSS 0.0133f
Rwire_oh1_20_ oh1[20] oh1_20__rc 52.7
Cwire1_oh1_21_ oh1[21] VSS 0.0104f
Cwire2_oh1_21_ oh1[21] VSS 0.0104f
Rwire_oh1_21_ oh1[21] oh1_21__rc 37.3
Cwire1_oh1_22_ oh1[22] VSS 0.0293f
Cwire2_oh1_22_ oh1[22] VSS 0.0293f
Rwire_oh1_22_ oh1[22] oh1_22__rc 68.8
Cwire1_oh1_23_ oh1[23] VSS 0.0100f
Cwire2_oh1_23_ oh1[23] VSS 0.0100f
Rwire_oh1_23_ oh1[23] oh1_23__rc 36.6
Cwire1_oh1_24_ oh1[24] VSS 0.1321f
Cwire2_oh1_24_ oh1[24] VSS 0.1321f
Rwire_oh1_24_ oh1[24] oh1_24__rc 237.6
Cwire1_oh1_25_ oh1[25] VSS 0.0734f
Cwire2_oh1_25_ oh1[25] VSS 0.0734f
Rwire_oh1_25_ oh1[25] oh1_25__rc 122.3
Cwire1_oh1_26_ oh1[26] VSS 0.0564f
Cwire2_oh1_26_ oh1[26] VSS 0.0564f
Rwire_oh1_26_ oh1[26] oh1_26__rc 92.9
Cwire1_oh1_27_ oh1[27] VSS 0.0116f
Cwire2_oh1_27_ oh1[27] VSS 0.0116f
Rwire_oh1_27_ oh1[27] oh1_27__rc 39.3
Cwire1_oh1_28_ oh1[28] VSS 0.0100f
Cwire2_oh1_28_ oh1[28] VSS 0.0100f
Rwire_oh1_28_ oh1[28] oh1_28__rc 36.6
Cwire1_oh1_29_ oh1[29] VSS 0.0085f
Cwire2_oh1_29_ oh1[29] VSS 0.0085f
Rwire_oh1_29_ oh1[29] oh1_29__rc 34.2
Cwire1_oh1_2_ oh1[2] VSS 0.0509f
Cwire2_oh1_2_ oh1[2] VSS 0.0509f
Rwire_oh1_2_ oh1[2] oh1_2__rc 81.6
Cwire1_oh1_30_ oh1[30] VSS 0.0230f
Cwire2_oh1_30_ oh1[30] VSS 0.0230f
Rwire_oh1_30_ oh1[30] oh1_30__rc 58.2
Cwire1_oh1_31_ oh1[31] VSS 0.0096f
Cwire2_oh1_31_ oh1[31] VSS 0.0096f
Rwire_oh1_31_ oh1[31] oh1_31__rc 36.0
Cwire1_oh1_3_ oh1[3] VSS 0.0739f
Cwire2_oh1_3_ oh1[3] VSS 0.0739f
Rwire_oh1_3_ oh1[3] oh1_3__rc 104.2
Cwire1_oh1_4_ oh1[4] VSS 0.0768f
Cwire2_oh1_4_ oh1[4] VSS 0.0768f
Rwire_oh1_4_ oh1[4] oh1_4__rc 156.2
Cwire1_oh1_5_ oh1[5] VSS 0.0293f
Cwire2_oh1_5_ oh1[5] VSS 0.0293f
Rwire_oh1_5_ oh1[5] oh1_5__rc 68.8
Cwire1_oh1_6_ oh1[6] VSS 0.0251f
Cwire2_oh1_6_ oh1[6] VSS 0.0251f
Rwire_oh1_6_ oh1[6] oh1_6__rc 67.7
Cwire1_oh1_7_ oh1[7] VSS 0.0103f
Cwire2_oh1_7_ oh1[7] VSS 0.0103f
Rwire_oh1_7_ oh1[7] oh1_7__rc 37.1
Cwire1_oh1_8_ oh1[8] VSS 0.0274f
Cwire2_oh1_8_ oh1[8] VSS 0.0274f
Rwire_oh1_8_ oh1[8] oh1_8__rc 65.7
Cwire1_oh1_9_ oh1[9] VSS 0.0896f
Cwire2_oh1_9_ oh1[9] VSS 0.0896f
Rwire_oh1_9_ oh1[9] oh1_9__rc 144.4
Cwire1_oh2_0_ oh2[0] VSS 0.0331f
Cwire2_oh2_0_ oh2[0] VSS 0.0331f
Rwire_oh2_0_ oh2[0] oh2_0__rc 75.1
Cwire1_oh2_10_ oh2[10] VSS 0.0608f
Cwire2_oh2_10_ oh2[10] VSS 0.0608f
Rwire_oh2_10_ oh2[10] oh2_10__rc 136.9
Cwire1_oh2_11_ oh2[11] VSS 0.0700f
Cwire2_oh2_11_ oh2[11] VSS 0.0700f
Rwire_oh2_11_ oh2[11] oh2_11__rc 128.4
Cwire1_oh2_12_ oh2[12] VSS 0.0411f
Cwire2_oh2_12_ oh2[12] VSS 0.0411f
Rwire_oh2_12_ oh2[12] oh2_12__rc 97.6
Cwire1_oh2_13_ oh2[13] VSS 0.0728f
Cwire2_oh2_13_ oh2[13] VSS 0.0728f
Rwire_oh2_13_ oh2[13] oh2_13__rc 142.5
Cwire1_oh2_14_ oh2[14] VSS 0.0510f
Cwire2_oh2_14_ oh2[14] VSS 0.0510f
Rwire_oh2_14_ oh2[14] oh2_14__rc 102.6
Cwire1_oh2_15_ oh2[15] VSS 0.0524f
Cwire2_oh2_15_ oh2[15] VSS 0.0524f
Rwire_oh2_15_ oh2[15] oh2_15__rc 105.7
Cwire1_oh2_16_ oh2[16] VSS 0.0444f
Cwire2_oh2_16_ oh2[16] VSS 0.0444f
Rwire_oh2_16_ oh2[16] oh2_16__rc 94.0
Cwire1_oh2_17_ oh2[17] VSS 0.0322f
Cwire2_oh2_17_ oh2[17] VSS 0.0322f
Rwire_oh2_17_ oh2[17] oh2_17__rc 78.4
Cwire1_oh2_18_ oh2[18] VSS 0.0549f
Cwire2_oh2_18_ oh2[18] VSS 0.0549f
Rwire_oh2_18_ oh2[18] oh2_18__rc 120.7
Cwire1_oh2_19_ oh2[19] VSS 0.0161f
Cwire2_oh2_19_ oh2[19] VSS 0.0161f
Rwire_oh2_19_ oh2[19] oh2_19__rc 46.8
Cwire1_oh2_1_ oh2[1] VSS 0.0133f
Cwire2_oh2_1_ oh2[1] VSS 0.0133f
Rwire_oh2_1_ oh2[1] oh2_1__rc 52.7
Cwire1_oh2_20_ oh2[20] VSS 0.0520f
Cwire2_oh2_20_ oh2[20] VSS 0.0520f
Rwire_oh2_20_ oh2[20] oh2_20__rc 127.9
Cwire1_oh2_21_ oh2[21] VSS 0.0485f
Cwire2_oh2_21_ oh2[21] VSS 0.0485f
Rwire_oh2_21_ oh2[21] oh2_21__rc 93.8
Cwire1_oh2_22_ oh2[22] VSS 0.0333f
Cwire2_oh2_22_ oh2[22] VSS 0.0333f
Rwire_oh2_22_ oh2[22] oh2_22__rc 70.7
Cwire1_oh2_23_ oh2[23] VSS 0.0463f
Cwire2_oh2_23_ oh2[23] VSS 0.0463f
Rwire_oh2_23_ oh2[23] oh2_23__rc 97.2
Cwire1_oh2_24_ oh2[24] VSS 0.0293f
Cwire2_oh2_24_ oh2[24] VSS 0.0293f
Rwire_oh2_24_ oh2[24] oh2_24__rc 68.8
Cwire1_oh2_25_ oh2[25] VSS 0.0485f
Cwire2_oh2_25_ oh2[25] VSS 0.0485f
Rwire_oh2_25_ oh2[25] oh2_25__rc 93.8
Cwire1_oh2_26_ oh2[26] VSS 0.0387f
Cwire2_oh2_26_ oh2[26] VSS 0.0387f
Rwire_oh2_26_ oh2[26] oh2_26__rc 84.6
Cwire1_oh2_27_ oh2[27] VSS 0.0851f
Cwire2_oh2_27_ oh2[27] VSS 0.0851f
Rwire_oh2_27_ oh2[27] oh2_27__rc 172.4
Cwire1_oh2_28_ oh2[28] VSS 0.0540f
Cwire2_oh2_28_ oh2[28] VSS 0.0540f
Rwire_oh2_28_ oh2[28] oh2_28__rc 97.6
Cwire1_oh2_29_ oh2[29] VSS 0.0451f
Cwire2_oh2_29_ oh2[29] VSS 0.0451f
Rwire_oh2_29_ oh2[29] oh2_29__rc 88.1
Cwire1_oh2_2_ oh2[2] VSS 0.0419f
Cwire2_oh2_2_ oh2[2] VSS 0.0419f
Rwire_oh2_2_ oh2[2] oh2_2__rc 88.6
Cwire1_oh2_30_ oh2[30] VSS 0.0147f
Cwire2_oh2_30_ oh2[30] VSS 0.0147f
Rwire_oh2_30_ oh2[30] oh2_30__rc 59.7
Cwire1_oh2_31_ oh2[31] VSS 0.0189f
Cwire2_oh2_31_ oh2[31] VSS 0.0189f
Rwire_oh2_31_ oh2[31] oh2_31__rc 62.1
Cwire1_oh2_3_ oh2[3] VSS 0.0161f
Cwire2_oh2_3_ oh2[3] VSS 0.0161f
Rwire_oh2_3_ oh2[3] oh2_3__rc 46.8
Cwire1_oh2_4_ oh2[4] VSS 0.0553f
Cwire2_oh2_4_ oh2[4] VSS 0.0553f
Rwire_oh2_4_ oh2[4] oh2_4__rc 102.4
Cwire1_oh2_5_ oh2[5] VSS 0.0481f
Cwire2_oh2_5_ oh2[5] VSS 0.0481f
Rwire_oh2_5_ oh2[5] oh2_5__rc 95.6
Cwire1_oh2_6_ oh2[6] VSS 0.0453f
Cwire2_oh2_6_ oh2[6] VSS 0.0453f
Rwire_oh2_6_ oh2[6] oh2_6__rc 82.9
Cwire1_oh2_7_ oh2[7] VSS 0.0390f
Cwire2_oh2_7_ oh2[7] VSS 0.0390f
Rwire_oh2_7_ oh2[7] oh2_7__rc 81.1
Cwire1_oh2_8_ oh2[8] VSS 0.0544f
Cwire2_oh2_8_ oh2[8] VSS 0.0544f
Rwire_oh2_8_ oh2[8] oh2_8__rc 127.1
Cwire1_oh2_9_ oh2[9] VSS 0.0838f
Cwire2_oh2_9_ oh2[9] VSS 0.0838f
Rwire_oh2_9_ oh2[9] oh2_9__rc 102.5

* Ground caps for RC intermediate nodes
Crc0 A_0__rc VSS 0.01fF
Crc1 A_10__rc VSS 0.01fF
Crc2 A_11__rc VSS 0.01fF
Crc3 A_12__rc VSS 0.01fF
Crc4 A_13__rc VSS 0.01fF
Crc5 A_14__rc VSS 0.01fF
Crc6 A_15__rc VSS 0.01fF
Crc7 A_16__rc VSS 0.01fF
Crc8 A_17__rc VSS 0.01fF
Crc9 A_18__rc VSS 0.01fF
Crc10 A_19__rc VSS 0.01fF
Crc11 A_1__rc VSS 0.01fF
Crc12 A_20__rc VSS 0.01fF
Crc13 A_21__rc VSS 0.01fF
Crc14 A_22__rc VSS 0.01fF
Crc15 A_23__rc VSS 0.01fF
Crc16 A_24__rc VSS 0.01fF
Crc17 A_25__rc VSS 0.01fF
Crc18 A_26__rc VSS 0.01fF
Crc19 A_27__rc VSS 0.01fF
Crc20 A_28__rc VSS 0.01fF
Crc21 A_29__rc VSS 0.01fF
Crc22 A_2__rc VSS 0.01fF
Crc23 A_30__rc VSS 0.01fF
Crc24 A_31__rc VSS 0.01fF
Crc25 A_32__rc VSS 0.01fF
Crc26 A_33__rc VSS 0.01fF
Crc27 A_34__rc VSS 0.01fF
Crc28 A_35__rc VSS 0.01fF
Crc29 A_36__rc VSS 0.01fF
Crc30 A_37__rc VSS 0.01fF
Crc31 A_38__rc VSS 0.01fF
Crc32 A_39__rc VSS 0.01fF
Crc33 A_3__rc VSS 0.01fF
Crc34 A_40__rc VSS 0.01fF
Crc35 A_41__rc VSS 0.01fF
Crc36 A_42__rc VSS 0.01fF
Crc37 A_43__rc VSS 0.01fF
Crc38 A_44__rc VSS 0.01fF
Crc39 A_45__rc VSS 0.01fF
Crc40 A_46__rc VSS 0.01fF
Crc41 A_47__rc VSS 0.01fF
Crc42 A_48__rc VSS 0.01fF
Crc43 A_49__rc VSS 0.01fF
Crc44 A_4__rc VSS 0.01fF
Crc45 A_50__rc VSS 0.01fF
Crc46 A_51__rc VSS 0.01fF
Crc47 A_52__rc VSS 0.01fF
Crc48 A_53__rc VSS 0.01fF
Crc49 A_54__rc VSS 0.01fF
Crc50 A_55__rc VSS 0.01fF
Crc51 A_56__rc VSS 0.01fF
Crc52 A_57__rc VSS 0.01fF
Crc53 A_58__rc VSS 0.01fF
Crc54 A_59__rc VSS 0.01fF
Crc55 A_5__rc VSS 0.01fF
Crc56 A_60__rc VSS 0.01fF
Crc57 A_61__rc VSS 0.01fF
Crc58 A_62__rc VSS 0.01fF
Crc59 A_63__rc VSS 0.01fF
Crc60 A_6__rc VSS 0.01fF
Crc61 A_7__rc VSS 0.01fF
Crc62 A_8__rc VSS 0.01fF
Crc63 A_9__rc VSS 0.01fF
Crc64 B_0__rc VSS 0.01fF
Crc65 B_10__rc VSS 0.01fF
Crc66 B_11__rc VSS 0.01fF
Crc67 B_12__rc VSS 0.01fF
Crc68 B_13__rc VSS 0.01fF
Crc69 B_14__rc VSS 0.01fF
Crc70 B_15__rc VSS 0.01fF
Crc71 B_16__rc VSS 0.01fF
Crc72 B_17__rc VSS 0.01fF
Crc73 B_18__rc VSS 0.01fF
Crc74 B_19__rc VSS 0.01fF
Crc75 B_1__rc VSS 0.01fF
Crc76 B_20__rc VSS 0.01fF
Crc77 B_21__rc VSS 0.01fF
Crc78 B_22__rc VSS 0.01fF
Crc79 B_23__rc VSS 0.01fF
Crc80 B_24__rc VSS 0.01fF
Crc81 B_25__rc VSS 0.01fF
Crc82 B_26__rc VSS 0.01fF
Crc83 B_27__rc VSS 0.01fF
Crc84 B_28__rc VSS 0.01fF
Crc85 B_29__rc VSS 0.01fF
Crc86 B_2__rc VSS 0.01fF
Crc87 B_30__rc VSS 0.01fF
Crc88 B_31__rc VSS 0.01fF
Crc89 B_32__rc VSS 0.01fF
Crc90 B_33__rc VSS 0.01fF
Crc91 B_34__rc VSS 0.01fF
Crc92 B_35__rc VSS 0.01fF
Crc93 B_36__rc VSS 0.01fF
Crc94 B_37__rc VSS 0.01fF
Crc95 B_38__rc VSS 0.01fF
Crc96 B_39__rc VSS 0.01fF
Crc97 B_3__rc VSS 0.01fF
Crc98 B_40__rc VSS 0.01fF
Crc99 B_41__rc VSS 0.01fF
Crc100 B_42__rc VSS 0.01fF
Crc101 B_43__rc VSS 0.01fF
Crc102 B_44__rc VSS 0.01fF
Crc103 B_45__rc VSS 0.01fF
Crc104 B_46__rc VSS 0.01fF
Crc105 B_47__rc VSS 0.01fF
Crc106 B_48__rc VSS 0.01fF
Crc107 B_49__rc VSS 0.01fF
Crc108 B_4__rc VSS 0.01fF
Crc109 B_50__rc VSS 0.01fF
Crc110 B_51__rc VSS 0.01fF
Crc111 B_52__rc VSS 0.01fF
Crc112 B_53__rc VSS 0.01fF
Crc113 B_54__rc VSS 0.01fF
Crc114 B_55__rc VSS 0.01fF
Crc115 B_56__rc VSS 0.01fF
Crc116 B_57__rc VSS 0.01fF
Crc117 B_58__rc VSS 0.01fF
Crc118 B_59__rc VSS 0.01fF
Crc119 B_5__rc VSS 0.01fF
Crc120 B_60__rc VSS 0.01fF
Crc121 B_61__rc VSS 0.01fF
Crc122 B_62__rc VSS 0.01fF
Crc123 B_63__rc VSS 0.01fF
Crc124 B_6__rc VSS 0.01fF
Crc125 B_7__rc VSS 0.01fF
Crc126 B_8__rc VSS 0.01fF
Crc127 B_9__rc VSS 0.01fF
Crc128 hd_0__rc VSS 0.01fF
Crc129 hd_1__rc VSS 0.01fF
Crc130 hd_2__rc VSS 0.01fF
Crc131 hd_3__rc VSS 0.01fF
Crc132 hd_4__rc VSS 0.01fF
Crc133 hd_5__rc VSS 0.01fF
Crc134 hd_6__rc VSS 0.01fF
Crc135 noh1_0__rc VSS 0.01fF
Crc136 noh1_10__rc VSS 0.01fF
Crc137 noh1_11__rc VSS 0.01fF
Crc138 noh1_12__rc VSS 0.01fF
Crc139 noh1_13__rc VSS 0.01fF
Crc140 noh1_14__rc VSS 0.01fF
Crc141 noh1_15__rc VSS 0.01fF
Crc142 noh1_16__rc VSS 0.01fF
Crc143 noh1_17__rc VSS 0.01fF
Crc144 noh1_18__rc VSS 0.01fF
Crc145 noh1_19__rc VSS 0.01fF
Crc146 noh1_1__rc VSS 0.01fF
Crc147 noh1_20__rc VSS 0.01fF
Crc148 noh1_21__rc VSS 0.01fF
Crc149 noh1_22__rc VSS 0.01fF
Crc150 noh1_23__rc VSS 0.01fF
Crc151 noh1_24__rc VSS 0.01fF
Crc152 noh1_25__rc VSS 0.01fF
Crc153 noh1_26__rc VSS 0.01fF
Crc154 noh1_27__rc VSS 0.01fF
Crc155 noh1_28__rc VSS 0.01fF
Crc156 noh1_29__rc VSS 0.01fF
Crc157 noh1_2__rc VSS 0.01fF
Crc158 noh1_30__rc VSS 0.01fF
Crc159 noh1_31__rc VSS 0.01fF
Crc160 noh1_3__rc VSS 0.01fF
Crc161 noh1_4__rc VSS 0.01fF
Crc162 noh1_5__rc VSS 0.01fF
Crc163 noh1_6__rc VSS 0.01fF
Crc164 noh1_7__rc VSS 0.01fF
Crc165 noh1_8__rc VSS 0.01fF
Crc166 noh1_9__rc VSS 0.01fF
Crc167 noh2_0__rc VSS 0.01fF
Crc168 noh2_10__rc VSS 0.01fF
Crc169 noh2_11__rc VSS 0.01fF
Crc170 noh2_12__rc VSS 0.01fF
Crc171 noh2_13__rc VSS 0.01fF
Crc172 noh2_14__rc VSS 0.01fF
Crc173 noh2_15__rc VSS 0.01fF
Crc174 noh2_16__rc VSS 0.01fF
Crc175 noh2_17__rc VSS 0.01fF
Crc176 noh2_18__rc VSS 0.01fF
Crc177 noh2_19__rc VSS 0.01fF
Crc178 noh2_1__rc VSS 0.01fF
Crc179 noh2_20__rc VSS 0.01fF
Crc180 noh2_21__rc VSS 0.01fF
Crc181 noh2_22__rc VSS 0.01fF
Crc182 noh2_23__rc VSS 0.01fF
Crc183 noh2_24__rc VSS 0.01fF
Crc184 noh2_25__rc VSS 0.01fF
Crc185 noh2_26__rc VSS 0.01fF
Crc186 noh2_27__rc VSS 0.01fF
Crc187 noh2_28__rc VSS 0.01fF
Crc188 noh2_29__rc VSS 0.01fF
Crc189 noh2_2__rc VSS 0.01fF
Crc190 noh2_30__rc VSS 0.01fF
Crc191 noh2_31__rc VSS 0.01fF
Crc192 noh2_3__rc VSS 0.01fF
Crc193 noh2_4__rc VSS 0.01fF
Crc194 noh2_5__rc VSS 0.01fF
Crc195 noh2_6__rc VSS 0.01fF
Crc196 noh2_7__rc VSS 0.01fF
Crc197 noh2_8__rc VSS 0.01fF
Crc198 noh2_9__rc VSS 0.01fF
Crc199 oh0_16__rc VSS 0.01fF
Crc200 oh0_28__rc VSS 0.01fF
Crc201 oh0_31__rc VSS 0.01fF
Crc202 oh1_0__rc VSS 0.01fF
Crc203 oh1_10__rc VSS 0.01fF
Crc204 oh1_11__rc VSS 0.01fF
Crc205 oh1_12__rc VSS 0.01fF
Crc206 oh1_13__rc VSS 0.01fF
Crc207 oh1_14__rc VSS 0.01fF
Crc208 oh1_15__rc VSS 0.01fF
Crc209 oh1_16__rc VSS 0.01fF
Crc210 oh1_17__rc VSS 0.01fF
Crc211 oh1_18__rc VSS 0.01fF
Crc212 oh1_19__rc VSS 0.01fF
Crc213 oh1_1__rc VSS 0.01fF
Crc214 oh1_20__rc VSS 0.01fF
Crc215 oh1_21__rc VSS 0.01fF
Crc216 oh1_22__rc VSS 0.01fF
Crc217 oh1_23__rc VSS 0.01fF
Crc218 oh1_24__rc VSS 0.01fF
Crc219 oh1_25__rc VSS 0.01fF
Crc220 oh1_26__rc VSS 0.01fF
Crc221 oh1_27__rc VSS 0.01fF
Crc222 oh1_28__rc VSS 0.01fF
Crc223 oh1_29__rc VSS 0.01fF
Crc224 oh1_2__rc VSS 0.01fF
Crc225 oh1_30__rc VSS 0.01fF
Crc226 oh1_31__rc VSS 0.01fF
Crc227 oh1_3__rc VSS 0.01fF
Crc228 oh1_4__rc VSS 0.01fF
Crc229 oh1_5__rc VSS 0.01fF
Crc230 oh1_6__rc VSS 0.01fF
Crc231 oh1_7__rc VSS 0.01fF
Crc232 oh1_8__rc VSS 0.01fF
Crc233 oh1_9__rc VSS 0.01fF
Crc234 oh2_0__rc VSS 0.01fF
Crc235 oh2_10__rc VSS 0.01fF
Crc236 oh2_11__rc VSS 0.01fF
Crc237 oh2_12__rc VSS 0.01fF
Crc238 oh2_13__rc VSS 0.01fF
Crc239 oh2_14__rc VSS 0.01fF
Crc240 oh2_15__rc VSS 0.01fF
Crc241 oh2_16__rc VSS 0.01fF
Crc242 oh2_17__rc VSS 0.01fF
Crc243 oh2_18__rc VSS 0.01fF
Crc244 oh2_19__rc VSS 0.01fF
Crc245 oh2_1__rc VSS 0.01fF
Crc246 oh2_20__rc VSS 0.01fF
Crc247 oh2_21__rc VSS 0.01fF
Crc248 oh2_22__rc VSS 0.01fF
Crc249 oh2_23__rc VSS 0.01fF
Crc250 oh2_24__rc VSS 0.01fF
Crc251 oh2_25__rc VSS 0.01fF
Crc252 oh2_26__rc VSS 0.01fF
Crc253 oh2_27__rc VSS 0.01fF
Crc254 oh2_28__rc VSS 0.01fF
Crc255 oh2_29__rc VSS 0.01fF
Crc256 oh2_2__rc VSS 0.01fF
Crc257 oh2_30__rc VSS 0.01fF
Crc258 oh2_31__rc VSS 0.01fF
Crc259 oh2_3__rc VSS 0.01fF
Crc260 oh2_4__rc VSS 0.01fF
Crc261 oh2_5__rc VSS 0.01fF
Crc262 oh2_6__rc VSS 0.01fF
Crc263 oh2_7__rc VSS 0.01fF
Crc264 oh2_8__rc VSS 0.01fF
Crc265 oh2_9__rc VSS 0.01fF

* 266 nets with RC parasitics
* 1564 transistors total

Cload0 hd[0] VSS 1fF
Cload1 hd[1] VSS 1fF
Cload2 hd[2] VSS 1fF
Cload3 hd[3] VSS 1fF
Cload4 hd[4] VSS 1fF
Cload5 hd[5] VSS 1fF
Cload6 hd[6] VSS 1fF

* === 50 vectors, 5.0ns, 0.1ns rise/fall ===
Va0 A[0] 0 PWL(0.00n 0.0 4.89n 0.0 5.00n 0.5 9.89n 0.5 10.00n 0.5 14.89n 0.5 15.00n 0.0 19.89n 0.0 20.00n 0.0 24.89n 0.0 25.00n 0.0 29.89n 0.0 30.00n 0.0 34.89n 0.0 35.00n 0.0 39.89n 0.0 40.00n 0.5 44.89n 0.5 45.00n 0.0 49.89n 0.0 50.00n 0.5 54.89n 0.5 55.00n 0.5 59.89n 0.5 60.00n 0.5 64.89n 0.5 65.00n 0.5 69.89n 0.5 70.00n 0.0 74.89n 0.0 75.00n 0.5 79.89n 0.5 80.00n 0.5 84.89n 0.5 85.00n 0.5 89.89n 0.5 90.00n 0.0 94.89n 0.0 95.00n 0.5 99.89n 0.5 100.00n 0.0 104.89n 0.0 105.00n 0.0 109.89n 0.0 110.00n 0.5 114.89n 0.5 115.00n 0.0 119.89n 0.0 120.00n 0.5 124.89n 0.5 125.00n 0.5 129.89n 0.5 130.00n 0.0 134.89n 0.0 135.00n 0.0 139.89n 0.0 140.00n 0.5 144.89n 0.5 145.00n 0.0 149.89n 0.0 150.00n 0.0 154.89n 0.0 155.00n 0.5 159.89n 0.5 160.00n 0.5 164.89n 0.5 165.00n 0.5 169.89n 0.5 170.00n 0.0 174.89n 0.0 175.00n 0.5 179.89n 0.5 180.00n 0.5 184.89n 0.5 185.00n 0.0 189.89n 0.0 190.00n 0.5 194.89n 0.5 195.00n 0.5 199.89n 0.5 200.00n 0.0 204.89n 0.0 205.00n 0.0 209.89n 0.0 210.00n 0.0 214.89n 0.0 215.00n 0.0 219.89n 0.0 220.00n 0.0 224.89n 0.0 225.00n 0.5 229.89n 0.5 230.00n 0.5 234.89n 0.5 235.00n 0.0 239.89n 0.0 240.00n 0.5 244.89n 0.5 245.00n 0.5 249.89n 0.5)
Vb0 B[0] 0 PWL(0.00n 0.5 4.89n 0.5 5.00n 0.5 9.89n 0.5 10.00n 0.5 14.89n 0.5 15.00n 0.0 19.89n 0.0 20.00n 0.5 24.89n 0.5 25.00n 0.0 29.89n 0.0 30.00n 0.0 34.89n 0.0 35.00n 0.0 39.89n 0.0 40.00n 0.5 44.89n 0.5 45.00n 0.5 49.89n 0.5 50.00n 0.0 54.89n 0.0 55.00n 0.0 59.89n 0.0 60.00n 0.0 64.89n 0.0 65.00n 0.5 69.89n 0.5 70.00n 0.0 74.89n 0.0 75.00n 0.0 79.89n 0.0 80.00n 0.0 84.89n 0.0 85.00n 0.0 89.89n 0.0 90.00n 0.5 94.89n 0.5 95.00n 0.5 99.89n 0.5 100.00n 0.0 104.89n 0.0 105.00n 0.5 109.89n 0.5 110.00n 0.5 114.89n 0.5 115.00n 0.5 119.89n 0.5 120.00n 0.0 124.89n 0.0 125.00n 0.5 129.89n 0.5 130.00n 0.0 134.89n 0.0 135.00n 0.5 139.89n 0.5 140.00n 0.5 144.89n 0.5 145.00n 0.5 149.89n 0.5 150.00n 0.5 154.89n 0.5 155.00n 0.0 159.89n 0.0 160.00n 0.0 164.89n 0.0 165.00n 0.0 169.89n 0.0 170.00n 0.0 174.89n 0.0 175.00n 0.0 179.89n 0.0 180.00n 0.5 184.89n 0.5 185.00n 0.0 189.89n 0.0 190.00n 0.0 194.89n 0.0 195.00n 0.0 199.89n 0.0 200.00n 0.0 204.89n 0.0 205.00n 0.5 209.89n 0.5 210.00n 0.0 214.89n 0.0 215.00n 0.5 219.89n 0.5 220.00n 0.5 224.89n 0.5 225.00n 0.0 229.89n 0.0 230.00n 0.0 234.89n 0.0 235.00n 0.0 239.89n 0.0 240.00n 0.0 244.89n 0.0 245.00n 0.0 249.89n 0.0)
Va1 A[1] 0 PWL(0.00n 0.0 4.89n 0.0 5.00n 0.5 9.89n 0.5 10.00n 0.5 14.89n 0.5 15.00n 0.5 19.89n 0.5 20.00n 0.0 24.89n 0.0 25.00n 0.5 29.89n 0.5 30.00n 0.0 34.89n 0.0 35.00n 0.0 39.89n 0.0 40.00n 0.0 44.89n 0.0 45.00n 0.5 49.89n 0.5 50.00n 0.5 54.89n 0.5 55.00n 0.0 59.89n 0.0 60.00n 0.0 64.89n 0.0 65.00n 0.0 69.89n 0.0 70.00n 0.5 74.89n 0.5 75.00n 0.0 79.89n 0.0 80.00n 0.0 84.89n 0.0 85.00n 0.0 89.89n 0.0 90.00n 0.0 94.89n 0.0 95.00n 0.5 99.89n 0.5 100.00n 0.5 104.89n 0.5 105.00n 0.0 109.89n 0.0 110.00n 0.5 114.89n 0.5 115.00n 0.5 119.89n 0.5 120.00n 0.5 124.89n 0.5 125.00n 0.0 129.89n 0.0 130.00n 0.5 134.89n 0.5 135.00n 0.0 139.89n 0.0 140.00n 0.5 144.89n 0.5 145.00n 0.5 149.89n 0.5 150.00n 0.5 154.89n 0.5 155.00n 0.5 159.89n 0.5 160.00n 0.0 164.89n 0.0 165.00n 0.0 169.89n 0.0 170.00n 0.0 174.89n 0.0 175.00n 0.0 179.89n 0.0 180.00n 0.0 184.89n 0.0 185.00n 0.5 189.89n 0.5 190.00n 0.0 194.89n 0.0 195.00n 0.0 199.89n 0.0 200.00n 0.0 204.89n 0.0 205.00n 0.0 209.89n 0.0 210.00n 0.5 214.89n 0.5 215.00n 0.0 219.89n 0.0 220.00n 0.5 224.89n 0.5 225.00n 0.5 229.89n 0.5 230.00n 0.0 234.89n 0.0 235.00n 0.0 239.89n 0.0 240.00n 0.0 244.89n 0.0 245.00n 0.0 249.89n 0.0)
Vb1 B[1] 0 PWL(0.00n 0.0 4.89n 0.0 5.00n 0.5 9.89n 0.5 10.00n 0.5 14.89n 0.5 15.00n 0.0 19.89n 0.0 20.00n 0.0 24.89n 0.0 25.00n 0.0 29.89n 0.0 30.00n 0.0 34.89n 0.0 35.00n 0.0 39.89n 0.0 40.00n 0.5 44.89n 0.5 45.00n 0.0 49.89n 0.0 50.00n 0.5 54.89n 0.5 55.00n 0.5 59.89n 0.5 60.00n 0.5 64.89n 0.5 65.00n 0.5 69.89n 0.5 70.00n 0.0 74.89n 0.0 75.00n 0.5 79.89n 0.5 80.00n 0.5 84.89n 0.5 85.00n 0.5 89.89n 0.5 90.00n 0.0 94.89n 0.0 95.00n 0.5 99.89n 0.5 100.00n 0.0 104.89n 0.0 105.00n 0.0 109.89n 0.0 110.00n 0.5 114.89n 0.5 115.00n 0.0 119.89n 0.0 120.00n 0.5 124.89n 0.5 125.00n 0.5 129.89n 0.5 130.00n 0.0 134.89n 0.0 135.00n 0.0 139.89n 0.0 140.00n 0.5 144.89n 0.5 145.00n 0.0 149.89n 0.0 150.00n 0.0 154.89n 0.0 155.00n 0.5 159.89n 0.5 160.00n 0.5 164.89n 0.5 165.00n 0.5 169.89n 0.5 170.00n 0.0 174.89n 0.0 175.00n 0.5 179.89n 0.5 180.00n 0.5 184.89n 0.5 185.00n 0.0 189.89n 0.0 190.00n 0.5 194.89n 0.5 195.00n 0.5 199.89n 0.5 200.00n 0.0 204.89n 0.0 205.00n 0.0 209.89n 0.0 210.00n 0.0 214.89n 0.0 215.00n 0.0 219.89n 0.0 220.00n 0.0 224.89n 0.0 225.00n 0.5 229.89n 0.5 230.00n 0.5 234.89n 0.5 235.00n 0.0 239.89n 0.0 240.00n 0.5 244.89n 0.5 245.00n 0.5 249.89n 0.5)
Va2 A[2] 0 PWL(0.00n 0.5 4.89n 0.5 5.00n 0.0 9.89n 0.0 10.00n 0.5 14.89n 0.5 15.00n 0.5 19.89n 0.5 20.00n 0.0 24.89n 0.0 25.00n 0.0 29.89n 0.0 30.00n 0.0 34.89n 0.0 35.00n 0.0 39.89n 0.0 40.00n 0.0 44.89n 0.0 45.00n 0.5 49.89n 0.5 50.00n 0.0 54.89n 0.0 55.00n 0.5 59.89n 0.5 60.00n 0.5 64.89n 0.5 65.00n 0.5 69.89n 0.5 70.00n 0.5 74.89n 0.5 75.00n 0.0 79.89n 0.0 80.00n 0.5 84.89n 0.5 85.00n 0.5 89.89n 0.5 90.00n 0.5 94.89n 0.5 95.00n 0.0 99.89n 0.0 100.00n 0.5 104.89n 0.5 105.00n 0.0 109.89n 0.0 110.00n 0.0 114.89n 0.0 115.00n 0.5 119.89n 0.5 120.00n 0.0 124.89n 0.0 125.00n 0.5 129.89n 0.5 130.00n 0.5 134.89n 0.5 135.00n 0.0 139.89n 0.0 140.00n 0.0 144.89n 0.0 145.00n 0.5 149.89n 0.5 150.00n 0.0 154.89n 0.0 155.00n 0.0 159.89n 0.0 160.00n 0.5 164.89n 0.5 165.00n 0.5 169.89n 0.5 170.00n 0.5 174.89n 0.5 175.00n 0.0 179.89n 0.0 180.00n 0.5 184.89n 0.5 185.00n 0.5 189.89n 0.5 190.00n 0.0 194.89n 0.0 195.00n 0.5 199.89n 0.5 200.00n 0.5 204.89n 0.5 205.00n 0.0 209.89n 0.0 210.00n 0.0 214.89n 0.0 215.00n 0.0 219.89n 0.0 220.00n 0.0 224.89n 0.0 225.00n 0.0 229.89n 0.0 230.00n 0.5 234.89n 0.5 235.00n 0.5 239.89n 0.5 240.00n 0.0 244.89n 0.0 245.00n 0.5 249.89n 0.5)
Vb2 B[2] 0 PWL(0.00n 0.0 4.89n 0.0 5.00n 0.5 9.89n 0.5 10.00n 0.5 14.89n 0.5 15.00n 0.5 19.89n 0.5 20.00n 0.0 24.89n 0.0 25.00n 0.5 29.89n 0.5 30.00n 0.0 34.89n 0.0 35.00n 0.0 39.89n 0.0 40.00n 0.0 44.89n 0.0 45.00n 0.5 49.89n 0.5 50.00n 0.5 54.89n 0.5 55.00n 0.0 59.89n 0.0 60.00n 0.0 64.89n 0.0 65.00n 0.0 69.89n 0.0 70.00n 0.5 74.89n 0.5 75.00n 0.0 79.89n 0.0 80.00n 0.0 84.89n 0.0 85.00n 0.0 89.89n 0.0 90.00n 0.0 94.89n 0.0 95.00n 0.5 99.89n 0.5 100.00n 0.5 104.89n 0.5 105.00n 0.0 109.89n 0.0 110.00n 0.5 114.89n 0.5 115.00n 0.5 119.89n 0.5 120.00n 0.5 124.89n 0.5 125.00n 0.0 129.89n 0.0 130.00n 0.5 134.89n 0.5 135.00n 0.0 139.89n 0.0 140.00n 0.5 144.89n 0.5 145.00n 0.5 149.89n 0.5 150.00n 0.5 154.89n 0.5 155.00n 0.5 159.89n 0.5 160.00n 0.0 164.89n 0.0 165.00n 0.0 169.89n 0.0 170.00n 0.0 174.89n 0.0 175.00n 0.0 179.89n 0.0 180.00n 0.0 184.89n 0.0 185.00n 0.5 189.89n 0.5 190.00n 0.0 194.89n 0.0 195.00n 0.0 199.89n 0.0 200.00n 0.0 204.89n 0.0 205.00n 0.0 209.89n 0.0 210.00n 0.5 214.89n 0.5 215.00n 0.0 219.89n 0.0 220.00n 0.5 224.89n 0.5 225.00n 0.5 229.89n 0.5 230.00n 0.0 234.89n 0.0 235.00n 0.0 239.89n 0.0 240.00n 0.0 244.89n 0.0 245.00n 0.0 249.89n 0.0)
Va3 A[3] 0 PWL(0.00n 0.5 4.89n 0.5 5.00n 0.0 9.89n 0.0 10.00n 0.5 14.89n 0.5 15.00n 0.5 19.89n 0.5 20.00n 0.5 24.89n 0.5 25.00n 0.0 29.89n 0.0 30.00n 0.5 34.89n 0.5 35.00n 0.0 39.89n 0.0 40.00n 0.0 44.89n 0.0 45.00n 0.0 49.89n 0.0 50.00n 0.5 54.89n 0.5 55.00n 0.5 59.89n 0.5 60.00n 0.0 64.89n 0.0 65.00n 0.0 69.89n 0.0 70.00n 0.0 74.89n 0.0 75.00n 0.5 79.89n 0.5 80.00n 0.0 84.89n 0.0 85.00n 0.0 89.89n 0.0 90.00n 0.0 94.89n 0.0 95.00n 0.0 99.89n 0.0 100.00n 0.5 104.89n 0.5 105.00n 0.5 109.89n 0.5 110.00n 0.0 114.89n 0.0 115.00n 0.5 119.89n 0.5 120.00n 0.5 124.89n 0.5 125.00n 0.5 129.89n 0.5 130.00n 0.0 134.89n 0.0 135.00n 0.5 139.89n 0.5 140.00n 0.0 144.89n 0.0 145.00n 0.5 149.89n 0.5 150.00n 0.5 154.89n 0.5 155.00n 0.5 159.89n 0.5 160.00n 0.5 164.89n 0.5 165.00n 0.0 169.89n 0.0 170.00n 0.0 174.89n 0.0 175.00n 0.0 179.89n 0.0 180.00n 0.0 184.89n 0.0 185.00n 0.0 189.89n 0.0 190.00n 0.5 194.89n 0.5 195.00n 0.0 199.89n 0.0 200.00n 0.0 204.89n 0.0 205.00n 0.0 209.89n 0.0 210.00n 0.0 214.89n 0.0 215.00n 0.5 219.89n 0.5 220.00n 0.0 224.89n 0.0 225.00n 0.5 229.89n 0.5 230.00n 0.5 234.89n 0.5 235.00n 0.0 239.89n 0.0 240.00n 0.0 244.89n 0.0 245.00n 0.0 249.89n 0.0)
Vb3 B[3] 0 PWL(0.00n 0.5 4.89n 0.5 5.00n 0.0 9.89n 0.0 10.00n 0.5 14.89n 0.5 15.00n 0.5 19.89n 0.5 20.00n 0.0 24.89n 0.0 25.00n 0.0 29.89n 0.0 30.00n 0.0 34.89n 0.0 35.00n 0.0 39.89n 0.0 40.00n 0.0 44.89n 0.0 45.00n 0.5 49.89n 0.5 50.00n 0.0 54.89n 0.0 55.00n 0.5 59.89n 0.5 60.00n 0.5 64.89n 0.5 65.00n 0.5 69.89n 0.5 70.00n 0.5 74.89n 0.5 75.00n 0.0 79.89n 0.0 80.00n 0.5 84.89n 0.5 85.00n 0.5 89.89n 0.5 90.00n 0.5 94.89n 0.5 95.00n 0.0 99.89n 0.0 100.00n 0.5 104.89n 0.5 105.00n 0.0 109.89n 0.0 110.00n 0.0 114.89n 0.0 115.00n 0.5 119.89n 0.5 120.00n 0.0 124.89n 0.0 125.00n 0.5 129.89n 0.5 130.00n 0.5 134.89n 0.5 135.00n 0.0 139.89n 0.0 140.00n 0.0 144.89n 0.0 145.00n 0.5 149.89n 0.5 150.00n 0.0 154.89n 0.0 155.00n 0.0 159.89n 0.0 160.00n 0.5 164.89n 0.5 165.00n 0.5 169.89n 0.5 170.00n 0.5 174.89n 0.5 175.00n 0.0 179.89n 0.0 180.00n 0.5 184.89n 0.5 185.00n 0.5 189.89n 0.5 190.00n 0.0 194.89n 0.0 195.00n 0.5 199.89n 0.5 200.00n 0.5 204.89n 0.5 205.00n 0.0 209.89n 0.0 210.00n 0.0 214.89n 0.0 215.00n 0.0 219.89n 0.0 220.00n 0.0 224.89n 0.0 225.00n 0.0 229.89n 0.0 230.00n 0.5 234.89n 0.5 235.00n 0.5 239.89n 0.5 240.00n 0.0 244.89n 0.0 245.00n 0.5 249.89n 0.5)
Va4 A[4] 0 PWL(0.00n 0.5 4.89n 0.5 5.00n 0.5 9.89n 0.5 10.00n 0.0 14.89n 0.0 15.00n 0.5 19.89n 0.5 20.00n 0.5 24.89n 0.5 25.00n 0.0 29.89n 0.0 30.00n 0.0 34.89n 0.0 35.00n 0.0 39.89n 0.0 40.00n 0.0 44.89n 0.0 45.00n 0.0 49.89n 0.0 50.00n 0.5 54.89n 0.5 55.00n 0.0 59.89n 0.0 60.00n 0.5 64.89n 0.5 65.00n 0.5 69.89n 0.5 70.00n 0.5 74.89n 0.5 75.00n 0.5 79.89n 0.5 80.00n 0.0 84.89n 0.0 85.00n 0.5 89.89n 0.5 90.00n 0.5 94.89n 0.5 95.00n 0.5 99.89n 0.5 100.00n 0.0 104.89n 0.0 105.00n 0.5 109.89n 0.5 110.00n 0.0 114.89n 0.0 115.00n 0.0 119.89n 0.0 120.00n 0.5 124.89n 0.5 125.00n 0.0 129.89n 0.0 130.00n 0.5 134.89n 0.5 135.00n 0.5 139.89n 0.5 140.00n 0.0 144.89n 0.0 145.00n 0.0 149.89n 0.0 150.00n 0.5 154.89n 0.5 155.00n 0.0 159.89n 0.0 160.00n 0.0 164.89n 0.0 165.00n 0.5 169.89n 0.5 170.00n 0.5 174.89n 0.5 175.00n 0.5 179.89n 0.5 180.00n 0.0 184.89n 0.0 185.00n 0.5 189.89n 0.5 190.00n 0.5 194.89n 0.5 195.00n 0.0 199.89n 0.0 200.00n 0.5 204.89n 0.5 205.00n 0.5 209.89n 0.5 210.00n 0.0 214.89n 0.0 215.00n 0.0 219.89n 0.0 220.00n 0.0 224.89n 0.0 225.00n 0.0 229.89n 0.0 230.00n 0.0 234.89n 0.0 235.00n 0.5 239.89n 0.5 240.00n 0.5 244.89n 0.5 245.00n 0.0 249.89n 0.0)
Vb4 B[4] 0 PWL(0.00n 0.5 4.89n 0.5 5.00n 0.0 9.89n 0.0 10.00n 0.5 14.89n 0.5 15.00n 0.5 19.89n 0.5 20.00n 0.5 24.89n 0.5 25.00n 0.0 29.89n 0.0 30.00n 0.5 34.89n 0.5 35.00n 0.0 39.89n 0.0 40.00n 0.0 44.89n 0.0 45.00n 0.0 49.89n 0.0 50.00n 0.5 54.89n 0.5 55.00n 0.5 59.89n 0.5 60.00n 0.0 64.89n 0.0 65.00n 0.0 69.89n 0.0 70.00n 0.0 74.89n 0.0 75.00n 0.5 79.89n 0.5 80.00n 0.0 84.89n 0.0 85.00n 0.0 89.89n 0.0 90.00n 0.0 94.89n 0.0 95.00n 0.0 99.89n 0.0 100.00n 0.5 104.89n 0.5 105.00n 0.5 109.89n 0.5 110.00n 0.0 114.89n 0.0 115.00n 0.5 119.89n 0.5 120.00n 0.5 124.89n 0.5 125.00n 0.5 129.89n 0.5 130.00n 0.0 134.89n 0.0 135.00n 0.5 139.89n 0.5 140.00n 0.0 144.89n 0.0 145.00n 0.5 149.89n 0.5 150.00n 0.5 154.89n 0.5 155.00n 0.5 159.89n 0.5 160.00n 0.5 164.89n 0.5 165.00n 0.0 169.89n 0.0 170.00n 0.0 174.89n 0.0 175.00n 0.0 179.89n 0.0 180.00n 0.0 184.89n 0.0 185.00n 0.0 189.89n 0.0 190.00n 0.5 194.89n 0.5 195.00n 0.0 199.89n 0.0 200.00n 0.0 204.89n 0.0 205.00n 0.0 209.89n 0.0 210.00n 0.0 214.89n 0.0 215.00n 0.5 219.89n 0.5 220.00n 0.0 224.89n 0.0 225.00n 0.5 229.89n 0.5 230.00n 0.5 234.89n 0.5 235.00n 0.0 239.89n 0.0 240.00n 0.0 244.89n 0.0 245.00n 0.0 249.89n 0.0)
Va5 A[5] 0 PWL(0.00n 0.5 4.89n 0.5 5.00n 0.5 9.89n 0.5 10.00n 0.0 14.89n 0.0 15.00n 0.5 19.89n 0.5 20.00n 0.5 24.89n 0.5 25.00n 0.5 29.89n 0.5 30.00n 0.0 34.89n 0.0 35.00n 0.5 39.89n 0.5 40.00n 0.0 44.89n 0.0 45.00n 0.0 49.89n 0.0 50.00n 0.0 54.89n 0.0 55.00n 0.5 59.89n 0.5 60.00n 0.5 64.89n 0.5 65.00n 0.0 69.89n 0.0 70.00n 0.0 74.89n 0.0 75.00n 0.0 79.89n 0.0 80.00n 0.5 84.89n 0.5 85.00n 0.0 89.89n 0.0 90.00n 0.0 94.89n 0.0 95.00n 0.0 99.89n 0.0 100.00n 0.0 104.89n 0.0 105.00n 0.5 109.89n 0.5 110.00n 0.5 114.89n 0.5 115.00n 0.0 119.89n 0.0 120.00n 0.5 124.89n 0.5 125.00n 0.5 129.89n 0.5 130.00n 0.5 134.89n 0.5 135.00n 0.0 139.89n 0.0 140.00n 0.5 144.89n 0.5 145.00n 0.0 149.89n 0.0 150.00n 0.5 154.89n 0.5 155.00n 0.5 159.89n 0.5 160.00n 0.5 164.89n 0.5 165.00n 0.5 169.89n 0.5 170.00n 0.0 174.89n 0.0 175.00n 0.0 179.89n 0.0 180.00n 0.0 184.89n 0.0 185.00n 0.0 189.89n 0.0 190.00n 0.0 194.89n 0.0 195.00n 0.5 199.89n 0.5 200.00n 0.0 204.89n 0.0 205.00n 0.0 209.89n 0.0 210.00n 0.0 214.89n 0.0 215.00n 0.0 219.89n 0.0 220.00n 0.5 224.89n 0.5 225.00n 0.0 229.89n 0.0 230.00n 0.5 234.89n 0.5 235.00n 0.5 239.89n 0.5 240.00n 0.0 244.89n 0.0 245.00n 0.0 249.89n 0.0)
Vb5 B[5] 0 PWL(0.00n 0.5 4.89n 0.5 5.00n 0.5 9.89n 0.5 10.00n 0.0 14.89n 0.0 15.00n 0.5 19.89n 0.5 20.00n 0.5 24.89n 0.5 25.00n 0.0 29.89n 0.0 30.00n 0.0 34.89n 0.0 35.00n 0.0 39.89n 0.0 40.00n 0.0 44.89n 0.0 45.00n 0.0 49.89n 0.0 50.00n 0.5 54.89n 0.5 55.00n 0.0 59.89n 0.0 60.00n 0.5 64.89n 0.5 65.00n 0.5 69.89n 0.5 70.00n 0.5 74.89n 0.5 75.00n 0.5 79.89n 0.5 80.00n 0.0 84.89n 0.0 85.00n 0.5 89.89n 0.5 90.00n 0.5 94.89n 0.5 95.00n 0.5 99.89n 0.5 100.00n 0.0 104.89n 0.0 105.00n 0.5 109.89n 0.5 110.00n 0.0 114.89n 0.0 115.00n 0.0 119.89n 0.0 120.00n 0.5 124.89n 0.5 125.00n 0.0 129.89n 0.0 130.00n 0.5 134.89n 0.5 135.00n 0.5 139.89n 0.5 140.00n 0.0 144.89n 0.0 145.00n 0.0 149.89n 0.0 150.00n 0.5 154.89n 0.5 155.00n 0.0 159.89n 0.0 160.00n 0.0 164.89n 0.0 165.00n 0.5 169.89n 0.5 170.00n 0.5 174.89n 0.5 175.00n 0.5 179.89n 0.5 180.00n 0.0 184.89n 0.0 185.00n 0.5 189.89n 0.5 190.00n 0.5 194.89n 0.5 195.00n 0.0 199.89n 0.0 200.00n 0.5 204.89n 0.5 205.00n 0.5 209.89n 0.5 210.00n 0.0 214.89n 0.0 215.00n 0.0 219.89n 0.0 220.00n 0.0 224.89n 0.0 225.00n 0.0 229.89n 0.0 230.00n 0.0 234.89n 0.0 235.00n 0.5 239.89n 0.5 240.00n 0.5 244.89n 0.5 245.00n 0.0 249.89n 0.0)
Va6 A[6] 0 PWL(0.00n 0.5 4.89n 0.5 5.00n 0.5 9.89n 0.5 10.00n 0.5 14.89n 0.5 15.00n 0.0 19.89n 0.0 20.00n 0.5 24.89n 0.5 25.00n 0.5 29.89n 0.5 30.00n 0.0 34.89n 0.0 35.00n 0.0 39.89n 0.0 40.00n 0.0 44.89n 0.0 45.00n 0.0 49.89n 0.0 50.00n 0.0 54.89n 0.0 55.00n 0.5 59.89n 0.5 60.00n 0.0 64.89n 0.0 65.00n 0.5 69.89n 0.5 70.00n 0.5 74.89n 0.5 75.00n 0.5 79.89n 0.5 80.00n 0.5 84.89n 0.5 85.00n 0.0 89.89n 0.0 90.00n 0.5 94.89n 0.5 95.00n 0.5 99.89n 0.5 100.00n 0.5 104.89n 0.5 105.00n 0.0 109.89n 0.0 110.00n 0.5 114.89n 0.5 115.00n 0.0 119.89n 0.0 120.00n 0.0 124.89n 0.0 125.00n 0.5 129.89n 0.5 130.00n 0.0 134.89n 0.0 135.00n 0.5 139.89n 0.5 140.00n 0.5 144.89n 0.5 145.00n 0.0 149.89n 0.0 150.00n 0.0 154.89n 0.0 155.00n 0.5 159.89n 0.5 160.00n 0.0 164.89n 0.0 165.00n 0.0 169.89n 0.0 170.00n 0.5 174.89n 0.5 175.00n 0.5 179.89n 0.5 180.00n 0.5 184.89n 0.5 185.00n 0.0 189.89n 0.0 190.00n 0.5 194.89n 0.5 195.00n 0.5 199.89n 0.5 200.00n 0.0 204.89n 0.0 205.00n 0.5 209.89n 0.5 210.00n 0.5 214.89n 0.5 215.00n 0.0 219.89n 0.0 220.00n 0.0 224.89n 0.0 225.00n 0.0 229.89n 0.0 230.00n 0.0 234.89n 0.0 235.00n 0.0 239.89n 0.0 240.00n 0.5 244.89n 0.5 245.00n 0.5 249.89n 0.5)
Vb6 B[6] 0 PWL(0.00n 0.5 4.89n 0.5 5.00n 0.5 9.89n 0.5 10.00n 0.0 14.89n 0.0 15.00n 0.5 19.89n 0.5 20.00n 0.5 24.89n 0.5 25.00n 0.5 29.89n 0.5 30.00n 0.0 34.89n 0.0 35.00n 0.5 39.89n 0.5 40.00n 0.0 44.89n 0.0 45.00n 0.0 49.89n 0.0 50.00n 0.0 54.89n 0.0 55.00n 0.5 59.89n 0.5 60.00n 0.5 64.89n 0.5 65.00n 0.0 69.89n 0.0 70.00n 0.0 74.89n 0.0 75.00n 0.0 79.89n 0.0 80.00n 0.5 84.89n 0.5 85.00n 0.0 89.89n 0.0 90.00n 0.0 94.89n 0.0 95.00n 0.0 99.89n 0.0 100.00n 0.0 104.89n 0.0 105.00n 0.5 109.89n 0.5 110.00n 0.5 114.89n 0.5 115.00n 0.0 119.89n 0.0 120.00n 0.5 124.89n 0.5 125.00n 0.5 129.89n 0.5 130.00n 0.5 134.89n 0.5 135.00n 0.0 139.89n 0.0 140.00n 0.5 144.89n 0.5 145.00n 0.0 149.89n 0.0 150.00n 0.5 154.89n 0.5 155.00n 0.5 159.89n 0.5 160.00n 0.5 164.89n 0.5 165.00n 0.5 169.89n 0.5 170.00n 0.0 174.89n 0.0 175.00n 0.0 179.89n 0.0 180.00n 0.0 184.89n 0.0 185.00n 0.0 189.89n 0.0 190.00n 0.0 194.89n 0.0 195.00n 0.5 199.89n 0.5 200.00n 0.0 204.89n 0.0 205.00n 0.0 209.89n 0.0 210.00n 0.0 214.89n 0.0 215.00n 0.0 219.89n 0.0 220.00n 0.5 224.89n 0.5 225.00n 0.0 229.89n 0.0 230.00n 0.5 234.89n 0.5 235.00n 0.5 239.89n 0.5 240.00n 0.0 244.89n 0.0 245.00n 0.0 249.89n 0.0)
Va7 A[7] 0 PWL(0.00n 0.0 4.89n 0.0 5.00n 0.5 9.89n 0.5 10.00n 0.5 14.89n 0.5 15.00n 0.0 19.89n 0.0 20.00n 0.5 24.89n 0.5 25.00n 0.5 29.89n 0.5 30.00n 0.5 34.89n 0.5 35.00n 0.0 39.89n 0.0 40.00n 0.5 44.89n 0.5 45.00n 0.0 49.89n 0.0 50.00n 0.0 54.89n 0.0 55.00n 0.0 59.89n 0.0 60.00n 0.5 64.89n 0.5 65.00n 0.5 69.89n 0.5 70.00n 0.0 74.89n 0.0 75.00n 0.0 79.89n 0.0 80.00n 0.0 84.89n 0.0 85.00n 0.5 89.89n 0.5 90.00n 0.0 94.89n 0.0 95.00n 0.0 99.89n 0.0 100.00n 0.0 104.89n 0.0 105.00n 0.0 109.89n 0.0 110.00n 0.5 114.89n 0.5 115.00n 0.5 119.89n 0.5 120.00n 0.0 124.89n 0.0 125.00n 0.5 129.89n 0.5 130.00n 0.5 134.89n 0.5 135.00n 0.5 139.89n 0.5 140.00n 0.0 144.89n 0.0 145.00n 0.5 149.89n 0.5 150.00n 0.0 154.89n 0.0 155.00n 0.5 159.89n 0.5 160.00n 0.5 164.89n 0.5 165.00n 0.5 169.89n 0.5 170.00n 0.5 174.89n 0.5 175.00n 0.0 179.89n 0.0 180.00n 0.0 184.89n 0.0 185.00n 0.0 189.89n 0.0 190.00n 0.0 194.89n 0.0 195.00n 0.0 199.89n 0.0 200.00n 0.5 204.89n 0.5 205.00n 0.0 209.89n 0.0 210.00n 0.0 214.89n 0.0 215.00n 0.0 219.89n 0.0 220.00n 0.0 224.89n 0.0 225.00n 0.5 229.89n 0.5 230.00n 0.0 234.89n 0.0 235.00n 0.5 239.89n 0.5 240.00n 0.5 244.89n 0.5 245.00n 0.0 249.89n 0.0)
Vb7 B[7] 0 PWL(0.00n 0.5 4.89n 0.5 5.00n 0.5 9.89n 0.5 10.00n 0.5 14.89n 0.5 15.00n 0.0 19.89n 0.0 20.00n 0.5 24.89n 0.5 25.00n 0.5 29.89n 0.5 30.00n 0.0 34.89n 0.0 35.00n 0.0 39.89n 0.0 40.00n 0.0 44.89n 0.0 45.00n 0.0 49.89n 0.0 50.00n 0.0 54.89n 0.0 55.00n 0.5 59.89n 0.5 60.00n 0.0 64.89n 0.0 65.00n 0.5 69.89n 0.5 70.00n 0.5 74.89n 0.5 75.00n 0.5 79.89n 0.5 80.00n 0.5 84.89n 0.5 85.00n 0.0 89.89n 0.0 90.00n 0.5 94.89n 0.5 95.00n 0.5 99.89n 0.5 100.00n 0.5 104.89n 0.5 105.00n 0.0 109.89n 0.0 110.00n 0.5 114.89n 0.5 115.00n 0.0 119.89n 0.0 120.00n 0.0 124.89n 0.0 125.00n 0.5 129.89n 0.5 130.00n 0.0 134.89n 0.0 135.00n 0.5 139.89n 0.5 140.00n 0.5 144.89n 0.5 145.00n 0.0 149.89n 0.0 150.00n 0.0 154.89n 0.0 155.00n 0.5 159.89n 0.5 160.00n 0.0 164.89n 0.0 165.00n 0.0 169.89n 0.0 170.00n 0.5 174.89n 0.5 175.00n 0.5 179.89n 0.5 180.00n 0.5 184.89n 0.5 185.00n 0.0 189.89n 0.0 190.00n 0.5 194.89n 0.5 195.00n 0.5 199.89n 0.5 200.00n 0.0 204.89n 0.0 205.00n 0.5 209.89n 0.5 210.00n 0.5 214.89n 0.5 215.00n 0.0 219.89n 0.0 220.00n 0.0 224.89n 0.0 225.00n 0.0 229.89n 0.0 230.00n 0.0 234.89n 0.0 235.00n 0.0 239.89n 0.0 240.00n 0.5 244.89n 0.5 245.00n 0.5 249.89n 0.5)
Va8 A[8] 0 PWL(0.00n 0.5 4.89n 0.5 5.00n 0.5 9.89n 0.5 10.00n 0.5 14.89n 0.5 15.00n 0.5 19.89n 0.5 20.00n 0.0 24.89n 0.0 25.00n 0.5 29.89n 0.5 30.00n 0.5 34.89n 0.5 35.00n 0.0 39.89n 0.0 40.00n 0.0 44.89n 0.0 45.00n 0.0 49.89n 0.0 50.00n 0.0 54.89n 0.0 55.00n 0.0 59.89n 0.0 60.00n 0.5 64.89n 0.5 65.00n 0.0 69.89n 0.0 70.00n 0.5 74.89n 0.5 75.00n 0.5 79.89n 0.5 80.00n 0.5 84.89n 0.5 85.00n 0.5 89.89n 0.5 90.00n 0.0 94.89n 0.0 95.00n 0.5 99.89n 0.5 100.00n 0.5 104.89n 0.5 105.00n 0.5 109.89n 0.5 110.00n 0.0 114.89n 0.0 115.00n 0.5 119.89n 0.5 120.00n 0.0 124.89n 0.0 125.00n 0.0 129.89n 0.0 130.00n 0.5 134.89n 0.5 135.00n 0.0 139.89n 0.0 140.00n 0.5 144.89n 0.5 145.00n 0.5 149.89n 0.5 150.00n 0.0 154.89n 0.0 155.00n 0.0 159.89n 0.0 160.00n 0.5 164.89n 0.5 165.00n 0.0 169.89n 0.0 170.00n 0.0 174.89n 0.0 175.00n 0.5 179.89n 0.5 180.00n 0.5 184.89n 0.5 185.00n 0.5 189.89n 0.5 190.00n 0.0 194.89n 0.0 195.00n 0.5 199.89n 0.5 200.00n 0.5 204.89n 0.5 205.00n 0.0 209.89n 0.0 210.00n 0.5 214.89n 0.5 215.00n 0.5 219.89n 0.5 220.00n 0.0 224.89n 0.0 225.00n 0.0 229.89n 0.0 230.00n 0.0 234.89n 0.0 235.00n 0.0 239.89n 0.0 240.00n 0.0 244.89n 0.0 245.00n 0.5 249.89n 0.5)
Vb8 B[8] 0 PWL(0.00n 0.0 4.89n 0.0 5.00n 0.5 9.89n 0.5 10.00n 0.5 14.89n 0.5 15.00n 0.0 19.89n 0.0 20.00n 0.5 24.89n 0.5 25.00n 0.5 29.89n 0.5 30.00n 0.5 34.89n 0.5 35.00n 0.0 39.89n 0.0 40.00n 0.5 44.89n 0.5 45.00n 0.0 49.89n 0.0 50.00n 0.0 54.89n 0.0 55.00n 0.0 59.89n 0.0 60.00n 0.5 64.89n 0.5 65.00n 0.5 69.89n 0.5 70.00n 0.0 74.89n 0.0 75.00n 0.0 79.89n 0.0 80.00n 0.0 84.89n 0.0 85.00n 0.5 89.89n 0.5 90.00n 0.0 94.89n 0.0 95.00n 0.0 99.89n 0.0 100.00n 0.0 104.89n 0.0 105.00n 0.0 109.89n 0.0 110.00n 0.5 114.89n 0.5 115.00n 0.5 119.89n 0.5 120.00n 0.0 124.89n 0.0 125.00n 0.5 129.89n 0.5 130.00n 0.5 134.89n 0.5 135.00n 0.5 139.89n 0.5 140.00n 0.0 144.89n 0.0 145.00n 0.5 149.89n 0.5 150.00n 0.0 154.89n 0.0 155.00n 0.5 159.89n 0.5 160.00n 0.5 164.89n 0.5 165.00n 0.5 169.89n 0.5 170.00n 0.5 174.89n 0.5 175.00n 0.0 179.89n 0.0 180.00n 0.0 184.89n 0.0 185.00n 0.0 189.89n 0.0 190.00n 0.0 194.89n 0.0 195.00n 0.0 199.89n 0.0 200.00n 0.5 204.89n 0.5 205.00n 0.0 209.89n 0.0 210.00n 0.0 214.89n 0.0 215.00n 0.0 219.89n 0.0 220.00n 0.0 224.89n 0.0 225.00n 0.5 229.89n 0.5 230.00n 0.0 234.89n 0.0 235.00n 0.5 239.89n 0.5 240.00n 0.5 244.89n 0.5 245.00n 0.0 249.89n 0.0)
Va9 A[9] 0 PWL(0.00n 0.0 4.89n 0.0 5.00n 0.0 9.89n 0.0 10.00n 0.5 14.89n 0.5 15.00n 0.5 19.89n 0.5 20.00n 0.0 24.89n 0.0 25.00n 0.5 29.89n 0.5 30.00n 0.5 34.89n 0.5 35.00n 0.5 39.89n 0.5 40.00n 0.0 44.89n 0.0 45.00n 0.5 49.89n 0.5 50.00n 0.0 54.89n 0.0 55.00n 0.0 59.89n 0.0 60.00n 0.0 64.89n 0.0 65.00n 0.5 69.89n 0.5 70.00n 0.5 74.89n 0.5 75.00n 0.0 79.89n 0.0 80.00n 0.0 84.89n 0.0 85.00n 0.0 89.89n 0.0 90.00n 0.5 94.89n 0.5 95.00n 0.0 99.89n 0.0 100.00n 0.0 104.89n 0.0 105.00n 0.0 109.89n 0.0 110.00n 0.0 114.89n 0.0 115.00n 0.5 119.89n 0.5 120.00n 0.5 124.89n 0.5 125.00n 0.0 129.89n 0.0 130.00n 0.5 134.89n 0.5 135.00n 0.5 139.89n 0.5 140.00n 0.5 144.89n 0.5 145.00n 0.0 149.89n 0.0 150.00n 0.5 154.89n 0.5 155.00n 0.0 159.89n 0.0 160.00n 0.5 164.89n 0.5 165.00n 0.5 169.89n 0.5 170.00n 0.5 174.89n 0.5 175.00n 0.5 179.89n 0.5 180.00n 0.0 184.89n 0.0 185.00n 0.0 189.89n 0.0 190.00n 0.0 194.89n 0.0 195.00n 0.0 199.89n 0.0 200.00n 0.0 204.89n 0.0 205.00n 0.5 209.89n 0.5 210.00n 0.0 214.89n 0.0 215.00n 0.0 219.89n 0.0 220.00n 0.0 224.89n 0.0 225.00n 0.0 229.89n 0.0 230.00n 0.5 234.89n 0.5 235.00n 0.0 239.89n 0.0 240.00n 0.5 244.89n 0.5 245.00n 0.5 249.89n 0.5)
Vb9 B[9] 0 PWL(0.00n 0.5 4.89n 0.5 5.00n 0.5 9.89n 0.5 10.00n 0.5 14.89n 0.5 15.00n 0.5 19.89n 0.5 20.00n 0.0 24.89n 0.0 25.00n 0.5 29.89n 0.5 30.00n 0.5 34.89n 0.5 35.00n 0.0 39.89n 0.0 40.00n 0.0 44.89n 0.0 45.00n 0.0 49.89n 0.0 50.00n 0.0 54.89n 0.0 55.00n 0.0 59.89n 0.0 60.00n 0.5 64.89n 0.5 65.00n 0.0 69.89n 0.0 70.00n 0.5 74.89n 0.5 75.00n 0.5 79.89n 0.5 80.00n 0.5 84.89n 0.5 85.00n 0.5 89.89n 0.5 90.00n 0.0 94.89n 0.0 95.00n 0.5 99.89n 0.5 100.00n 0.5 104.89n 0.5 105.00n 0.5 109.89n 0.5 110.00n 0.0 114.89n 0.0 115.00n 0.5 119.89n 0.5 120.00n 0.0 124.89n 0.0 125.00n 0.0 129.89n 0.0 130.00n 0.5 134.89n 0.5 135.00n 0.0 139.89n 0.0 140.00n 0.5 144.89n 0.5 145.00n 0.5 149.89n 0.5 150.00n 0.0 154.89n 0.0 155.00n 0.0 159.89n 0.0 160.00n 0.5 164.89n 0.5 165.00n 0.0 169.89n 0.0 170.00n 0.0 174.89n 0.0 175.00n 0.5 179.89n 0.5 180.00n 0.5 184.89n 0.5 185.00n 0.5 189.89n 0.5 190.00n 0.0 194.89n 0.0 195.00n 0.5 199.89n 0.5 200.00n 0.5 204.89n 0.5 205.00n 0.0 209.89n 0.0 210.00n 0.5 214.89n 0.5 215.00n 0.5 219.89n 0.5 220.00n 0.0 224.89n 0.0 225.00n 0.0 229.89n 0.0 230.00n 0.0 234.89n 0.0 235.00n 0.0 239.89n 0.0 240.00n 0.0 244.89n 0.0 245.00n 0.5 249.89n 0.5)
Va10 A[10] 0 PWL(0.00n 0.5 4.89n 0.5 5.00n 0.5 9.89n 0.5 10.00n 0.5 14.89n 0.5 15.00n 0.5 19.89n 0.5 20.00n 0.5 24.89n 0.5 25.00n 0.0 29.89n 0.0 30.00n 0.5 34.89n 0.5 35.00n 0.5 39.89n 0.5 40.00n 0.0 44.89n 0.0 45.00n 0.0 49.89n 0.0 50.00n 0.0 54.89n 0.0 55.00n 0.0 59.89n 0.0 60.00n 0.0 64.89n 0.0 65.00n 0.5 69.89n 0.5 70.00n 0.0 74.89n 0.0 75.00n 0.5 79.89n 0.5 80.00n 0.5 84.89n 0.5 85.00n 0.5 89.89n 0.5 90.00n 0.5 94.89n 0.5 95.00n 0.0 99.89n 0.0 100.00n 0.5 104.89n 0.5 105.00n 0.5 109.89n 0.5 110.00n 0.5 114.89n 0.5 115.00n 0.0 119.89n 0.0 120.00n 0.5 124.89n 0.5 125.00n 0.0 129.89n 0.0 130.00n 0.0 134.89n 0.0 135.00n 0.5 139.89n 0.5 140.00n 0.0 144.89n 0.0 145.00n 0.5 149.89n 0.5 150.00n 0.5 154.89n 0.5 155.00n 0.0 159.89n 0.0 160.00n 0.0 164.89n 0.0 165.00n 0.5 169.89n 0.5 170.00n 0.0 174.89n 0.0 175.00n 0.0 179.89n 0.0 180.00n 0.5 184.89n 0.5 185.00n 0.5 189.89n 0.5 190.00n 0.5 194.89n 0.5 195.00n 0.0 199.89n 0.0 200.00n 0.5 204.89n 0.5 205.00n 0.5 209.89n 0.5 210.00n 0.0 214.89n 0.0 215.00n 0.5 219.89n 0.5 220.00n 0.5 224.89n 0.5 225.00n 0.0 229.89n 0.0 230.00n 0.0 234.89n 0.0 235.00n 0.0 239.89n 0.0 240.00n 0.0 244.89n 0.0 245.00n 0.0 249.89n 0.0)
Vb10 B[10] 0 PWL(0.00n 0.0 4.89n 0.0 5.00n 0.0 9.89n 0.0 10.00n 0.5 14.89n 0.5 15.00n 0.5 19.89n 0.5 20.00n 0.0 24.89n 0.0 25.00n 0.5 29.89n 0.5 30.00n 0.5 34.89n 0.5 35.00n 0.5 39.89n 0.5 40.00n 0.0 44.89n 0.0 45.00n 0.5 49.89n 0.5 50.00n 0.0 54.89n 0.0 55.00n 0.0 59.89n 0.0 60.00n 0.0 64.89n 0.0 65.00n 0.5 69.89n 0.5 70.00n 0.5 74.89n 0.5 75.00n 0.0 79.89n 0.0 80.00n 0.0 84.89n 0.0 85.00n 0.0 89.89n 0.0 90.00n 0.5 94.89n 0.5 95.00n 0.0 99.89n 0.0 100.00n 0.0 104.89n 0.0 105.00n 0.0 109.89n 0.0 110.00n 0.0 114.89n 0.0 115.00n 0.5 119.89n 0.5 120.00n 0.5 124.89n 0.5 125.00n 0.0 129.89n 0.0 130.00n 0.5 134.89n 0.5 135.00n 0.5 139.89n 0.5 140.00n 0.5 144.89n 0.5 145.00n 0.0 149.89n 0.0 150.00n 0.5 154.89n 0.5 155.00n 0.0 159.89n 0.0 160.00n 0.5 164.89n 0.5 165.00n 0.5 169.89n 0.5 170.00n 0.5 174.89n 0.5 175.00n 0.5 179.89n 0.5 180.00n 0.0 184.89n 0.0 185.00n 0.0 189.89n 0.0 190.00n 0.0 194.89n 0.0 195.00n 0.0 199.89n 0.0 200.00n 0.0 204.89n 0.0 205.00n 0.5 209.89n 0.5 210.00n 0.0 214.89n 0.0 215.00n 0.0 219.89n 0.0 220.00n 0.0 224.89n 0.0 225.00n 0.0 229.89n 0.0 230.00n 0.5 234.89n 0.5 235.00n 0.0 239.89n 0.0 240.00n 0.5 244.89n 0.5 245.00n 0.5 249.89n 0.5)
Va11 A[11] 0 PWL(0.00n 0.0 4.89n 0.0 5.00n 0.0 9.89n 0.0 10.00n 0.0 14.89n 0.0 15.00n 0.5 19.89n 0.5 20.00n 0.5 24.89n 0.5 25.00n 0.0 29.89n 0.0 30.00n 0.5 34.89n 0.5 35.00n 0.5 39.89n 0.5 40.00n 0.5 44.89n 0.5 45.00n 0.0 49.89n 0.0 50.00n 0.5 54.89n 0.5 55.00n 0.0 59.89n 0.0 60.00n 0.0 64.89n 0.0 65.00n 0.0 69.89n 0.0 70.00n 0.5 74.89n 0.5 75.00n 0.5 79.89n 0.5 80.00n 0.0 84.89n 0.0 85.00n 0.0 89.89n 0.0 90.00n 0.0 94.89n 0.0 95.00n 0.5 99.89n 0.5 100.00n 0.0 104.89n 0.0 105.00n 0.0 109.89n 0.0 110.00n 0.0 114.89n 0.0 115.00n 0.0 119.89n 0.0 120.00n 0.5 124.89n 0.5 125.00n 0.5 129.89n 0.5 130.00n 0.0 134.89n 0.0 135.00n 0.5 139.89n 0.5 140.00n 0.5 144.89n 0.5 145.00n 0.5 149.89n 0.5 150.00n 0.0 154.89n 0.0 155.00n 0.5 159.89n 0.5 160.00n 0.0 164.89n 0.0 165.00n 0.5 169.89n 0.5 170.00n 0.5 174.89n 0.5 175.00n 0.5 179.89n 0.5 180.00n 0.5 184.89n 0.5 185.00n 0.0 189.89n 0.0 190.00n 0.0 194.89n 0.0 195.00n 0.0 199.89n 0.0 200.00n 0.0 204.89n 0.0 205.00n 0.0 209.89n 0.0 210.00n 0.5 214.89n 0.5 215.00n 0.0 219.89n 0.0 220.00n 0.0 224.89n 0.0 225.00n 0.0 229.89n 0.0 230.00n 0.0 234.89n 0.0 235.00n 0.5 239.89n 0.5 240.00n 0.0 244.89n 0.0 245.00n 0.5 249.89n 0.5)
Vb11 B[11] 0 PWL(0.00n 0.5 4.89n 0.5 5.00n 0.5 9.89n 0.5 10.00n 0.5 14.89n 0.5 15.00n 0.5 19.89n 0.5 20.00n 0.5 24.89n 0.5 25.00n 0.0 29.89n 0.0 30.00n 0.5 34.89n 0.5 35.00n 0.5 39.89n 0.5 40.00n 0.0 44.89n 0.0 45.00n 0.0 49.89n 0.0 50.00n 0.0 54.89n 0.0 55.00n 0.0 59.89n 0.0 60.00n 0.0 64.89n 0.0 65.00n 0.5 69.89n 0.5 70.00n 0.0 74.89n 0.0 75.00n 0.5 79.89n 0.5 80.00n 0.5 84.89n 0.5 85.00n 0.5 89.89n 0.5 90.00n 0.5 94.89n 0.5 95.00n 0.0 99.89n 0.0 100.00n 0.5 104.89n 0.5 105.00n 0.5 109.89n 0.5 110.00n 0.5 114.89n 0.5 115.00n 0.0 119.89n 0.0 120.00n 0.5 124.89n 0.5 125.00n 0.0 129.89n 0.0 130.00n 0.0 134.89n 0.0 135.00n 0.5 139.89n 0.5 140.00n 0.0 144.89n 0.0 145.00n 0.5 149.89n 0.5 150.00n 0.5 154.89n 0.5 155.00n 0.0 159.89n 0.0 160.00n 0.0 164.89n 0.0 165.00n 0.5 169.89n 0.5 170.00n 0.0 174.89n 0.0 175.00n 0.0 179.89n 0.0 180.00n 0.5 184.89n 0.5 185.00n 0.5 189.89n 0.5 190.00n 0.5 194.89n 0.5 195.00n 0.0 199.89n 0.0 200.00n 0.5 204.89n 0.5 205.00n 0.5 209.89n 0.5 210.00n 0.0 214.89n 0.0 215.00n 0.5 219.89n 0.5 220.00n 0.5 224.89n 0.5 225.00n 0.0 229.89n 0.0 230.00n 0.0 234.89n 0.0 235.00n 0.0 239.89n 0.0 240.00n 0.0 244.89n 0.0 245.00n 0.0 249.89n 0.0)
Va12 A[12] 0 PWL(0.00n 0.5 4.89n 0.5 5.00n 0.5 9.89n 0.5 10.00n 0.5 14.89n 0.5 15.00n 0.5 19.89n 0.5 20.00n 0.5 24.89n 0.5 25.00n 0.5 29.89n 0.5 30.00n 0.0 34.89n 0.0 35.00n 0.5 39.89n 0.5 40.00n 0.5 44.89n 0.5 45.00n 0.0 49.89n 0.0 50.00n 0.0 54.89n 0.0 55.00n 0.0 59.89n 0.0 60.00n 0.0 64.89n 0.0 65.00n 0.0 69.89n 0.0 70.00n 0.5 74.89n 0.5 75.00n 0.0 79.89n 0.0 80.00n 0.5 84.89n 0.5 85.00n 0.5 89.89n 0.5 90.00n 0.5 94.89n 0.5 95.00n 0.5 99.89n 0.5 100.00n 0.0 104.89n 0.0 105.00n 0.5 109.89n 0.5 110.00n 0.5 114.89n 0.5 115.00n 0.5 119.89n 0.5 120.00n 0.0 124.89n 0.0 125.00n 0.5 129.89n 0.5 130.00n 0.0 134.89n 0.0 135.00n 0.0 139.89n 0.0 140.00n 0.5 144.89n 0.5 145.00n 0.0 149.89n 0.0 150.00n 0.5 154.89n 0.5 155.00n 0.5 159.89n 0.5 160.00n 0.0 164.89n 0.0 165.00n 0.0 169.89n 0.0 170.00n 0.5 174.89n 0.5 175.00n 0.0 179.89n 0.0 180.00n 0.0 184.89n 0.0 185.00n 0.5 189.89n 0.5 190.00n 0.5 194.89n 0.5 195.00n 0.5 199.89n 0.5 200.00n 0.0 204.89n 0.0 205.00n 0.5 209.89n 0.5 210.00n 0.5 214.89n 0.5 215.00n 0.0 219.89n 0.0 220.00n 0.5 224.89n 0.5 225.00n 0.5 229.89n 0.5 230.00n 0.0 234.89n 0.0 235.00n 0.0 239.89n 0.0 240.00n 0.0 244.89n 0.0 245.00n 0.0 249.89n 0.0)
Vb12 B[12] 0 PWL(0.00n 0.0 4.89n 0.0 5.00n 0.0 9.89n 0.0 10.00n 0.0 14.89n 0.0 15.00n 0.5 19.89n 0.5 20.00n 0.5 24.89n 0.5 25.00n 0.0 29.89n 0.0 30.00n 0.5 34.89n 0.5 35.00n 0.5 39.89n 0.5 40.00n 0.5 44.89n 0.5 45.00n 0.0 49.89n 0.0 50.00n 0.5 54.89n 0.5 55.00n 0.0 59.89n 0.0 60.00n 0.0 64.89n 0.0 65.00n 0.0 69.89n 0.0 70.00n 0.5 74.89n 0.5 75.00n 0.5 79.89n 0.5 80.00n 0.0 84.89n 0.0 85.00n 0.0 89.89n 0.0 90.00n 0.0 94.89n 0.0 95.00n 0.5 99.89n 0.5 100.00n 0.0 104.89n 0.0 105.00n 0.0 109.89n 0.0 110.00n 0.0 114.89n 0.0 115.00n 0.0 119.89n 0.0 120.00n 0.5 124.89n 0.5 125.00n 0.5 129.89n 0.5 130.00n 0.0 134.89n 0.0 135.00n 0.5 139.89n 0.5 140.00n 0.5 144.89n 0.5 145.00n 0.5 149.89n 0.5 150.00n 0.0 154.89n 0.0 155.00n 0.5 159.89n 0.5 160.00n 0.0 164.89n 0.0 165.00n 0.5 169.89n 0.5 170.00n 0.5 174.89n 0.5 175.00n 0.5 179.89n 0.5 180.00n 0.5 184.89n 0.5 185.00n 0.0 189.89n 0.0 190.00n 0.0 194.89n 0.0 195.00n 0.0 199.89n 0.0 200.00n 0.0 204.89n 0.0 205.00n 0.0 209.89n 0.0 210.00n 0.5 214.89n 0.5 215.00n 0.0 219.89n 0.0 220.00n 0.0 224.89n 0.0 225.00n 0.0 229.89n 0.0 230.00n 0.0 234.89n 0.0 235.00n 0.5 239.89n 0.5 240.00n 0.0 244.89n 0.0 245.00n 0.5 249.89n 0.5)
Va13 A[13] 0 PWL(0.00n 0.5 4.89n 0.5 5.00n 0.0 9.89n 0.0 10.00n 0.0 14.89n 0.0 15.00n 0.0 19.89n 0.0 20.00n 0.5 24.89n 0.5 25.00n 0.5 29.89n 0.5 30.00n 0.0 34.89n 0.0 35.00n 0.5 39.89n 0.5 40.00n 0.5 44.89n 0.5 45.00n 0.5 49.89n 0.5 50.00n 0.0 54.89n 0.0 55.00n 0.5 59.89n 0.5 60.00n 0.0 64.89n 0.0 65.00n 0.0 69.89n 0.0 70.00n 0.0 74.89n 0.0 75.00n 0.5 79.89n 0.5 80.00n 0.5 84.89n 0.5 85.00n 0.0 89.89n 0.0 90.00n 0.0 94.89n 0.0 95.00n 0.0 99.89n 0.0 100.00n 0.5 104.89n 0.5 105.00n 0.0 109.89n 0.0 110.00n 0.0 114.89n 0.0 115.00n 0.0 119.89n 0.0 120.00n 0.0 124.89n 0.0 125.00n 0.5 129.89n 0.5 130.00n 0.5 134.89n 0.5 135.00n 0.0 139.89n 0.0 140.00n 0.5 144.89n 0.5 145.00n 0.5 149.89n 0.5 150.00n 0.5 154.89n 0.5 155.00n 0.0 159.89n 0.0 160.00n 0.5 164.89n 0.5 165.00n 0.0 169.89n 0.0 170.00n 0.5 174.89n 0.5 175.00n 0.5 179.89n 0.5 180.00n 0.5 184.89n 0.5 185.00n 0.5 189.89n 0.5 190.00n 0.0 194.89n 0.0 195.00n 0.0 199.89n 0.0 200.00n 0.0 204.89n 0.0 205.00n 0.0 209.89n 0.0 210.00n 0.0 214.89n 0.0 215.00n 0.5 219.89n 0.5 220.00n 0.0 224.89n 0.0 225.00n 0.0 229.89n 0.0 230.00n 0.0 234.89n 0.0 235.00n 0.0 239.89n 0.0 240.00n 0.5 244.89n 0.5 245.00n 0.0 249.89n 0.0)
Vb13 B[13] 0 PWL(0.00n 0.5 4.89n 0.5 5.00n 0.5 9.89n 0.5 10.00n 0.5 14.89n 0.5 15.00n 0.5 19.89n 0.5 20.00n 0.5 24.89n 0.5 25.00n 0.5 29.89n 0.5 30.00n 0.0 34.89n 0.0 35.00n 0.5 39.89n 0.5 40.00n 0.5 44.89n 0.5 45.00n 0.0 49.89n 0.0 50.00n 0.0 54.89n 0.0 55.00n 0.0 59.89n 0.0 60.00n 0.0 64.89n 0.0 65.00n 0.0 69.89n 0.0 70.00n 0.5 74.89n 0.5 75.00n 0.0 79.89n 0.0 80.00n 0.5 84.89n 0.5 85.00n 0.5 89.89n 0.5 90.00n 0.5 94.89n 0.5 95.00n 0.5 99.89n 0.5 100.00n 0.0 104.89n 0.0 105.00n 0.5 109.89n 0.5 110.00n 0.5 114.89n 0.5 115.00n 0.5 119.89n 0.5 120.00n 0.0 124.89n 0.0 125.00n 0.5 129.89n 0.5 130.00n 0.0 134.89n 0.0 135.00n 0.0 139.89n 0.0 140.00n 0.5 144.89n 0.5 145.00n 0.0 149.89n 0.0 150.00n 0.5 154.89n 0.5 155.00n 0.5 159.89n 0.5 160.00n 0.0 164.89n 0.0 165.00n 0.0 169.89n 0.0 170.00n 0.5 174.89n 0.5 175.00n 0.0 179.89n 0.0 180.00n 0.0 184.89n 0.0 185.00n 0.5 189.89n 0.5 190.00n 0.5 194.89n 0.5 195.00n 0.5 199.89n 0.5 200.00n 0.0 204.89n 0.0 205.00n 0.5 209.89n 0.5 210.00n 0.5 214.89n 0.5 215.00n 0.0 219.89n 0.0 220.00n 0.5 224.89n 0.5 225.00n 0.5 229.89n 0.5 230.00n 0.0 234.89n 0.0 235.00n 0.0 239.89n 0.0 240.00n 0.0 244.89n 0.0 245.00n 0.0 249.89n 0.0)
Va14 A[14] 0 PWL(0.00n 0.5 4.89n 0.5 5.00n 0.5 9.89n 0.5 10.00n 0.5 14.89n 0.5 15.00n 0.5 19.89n 0.5 20.00n 0.5 24.89n 0.5 25.00n 0.5 29.89n 0.5 30.00n 0.5 34.89n 0.5 35.00n 0.0 39.89n 0.0 40.00n 0.5 44.89n 0.5 45.00n 0.5 49.89n 0.5 50.00n 0.0 54.89n 0.0 55.00n 0.0 59.89n 0.0 60.00n 0.0 64.89n 0.0 65.00n 0.0 69.89n 0.0 70.00n 0.0 74.89n 0.0 75.00n 0.5 79.89n 0.5 80.00n 0.0 84.89n 0.0 85.00n 0.5 89.89n 0.5 90.00n 0.5 94.89n 0.5 95.00n 0.5 99.89n 0.5 100.00n 0.5 104.89n 0.5 105.00n 0.0 109.89n 0.0 110.00n 0.5 114.89n 0.5 115.00n 0.5 119.89n 0.5 120.00n 0.5 124.89n 0.5 125.00n 0.0 129.89n 0.0 130.00n 0.5 134.89n 0.5 135.00n 0.0 139.89n 0.0 140.00n 0.0 144.89n 0.0 145.00n 0.5 149.89n 0.5 150.00n 0.0 154.89n 0.0 155.00n 0.5 159.89n 0.5 160.00n 0.5 164.89n 0.5 165.00n 0.0 169.89n 0.0 170.00n 0.0 174.89n 0.0 175.00n 0.5 179.89n 0.5 180.00n 0.0 184.89n 0.0 185.00n 0.0 189.89n 0.0 190.00n 0.5 194.89n 0.5 195.00n 0.5 199.89n 0.5 200.00n 0.5 204.89n 0.5 205.00n 0.0 209.89n 0.0 210.00n 0.5 214.89n 0.5 215.00n 0.5 219.89n 0.5 220.00n 0.0 224.89n 0.0 225.00n 0.5 229.89n 0.5 230.00n 0.5 234.89n 0.5 235.00n 0.0 239.89n 0.0 240.00n 0.0 244.89n 0.0 245.00n 0.0 249.89n 0.0)
Vb14 B[14] 0 PWL(0.00n 0.5 4.89n 0.5 5.00n 0.0 9.89n 0.0 10.00n 0.0 14.89n 0.0 15.00n 0.0 19.89n 0.0 20.00n 0.5 24.89n 0.5 25.00n 0.5 29.89n 0.5 30.00n 0.0 34.89n 0.0 35.00n 0.5 39.89n 0.5 40.00n 0.5 44.89n 0.5 45.00n 0.5 49.89n 0.5 50.00n 0.0 54.89n 0.0 55.00n 0.5 59.89n 0.5 60.00n 0.0 64.89n 0.0 65.00n 0.0 69.89n 0.0 70.00n 0.0 74.89n 0.0 75.00n 0.5 79.89n 0.5 80.00n 0.5 84.89n 0.5 85.00n 0.0 89.89n 0.0 90.00n 0.0 94.89n 0.0 95.00n 0.0 99.89n 0.0 100.00n 0.5 104.89n 0.5 105.00n 0.0 109.89n 0.0 110.00n 0.0 114.89n 0.0 115.00n 0.0 119.89n 0.0 120.00n 0.0 124.89n 0.0 125.00n 0.5 129.89n 0.5 130.00n 0.5 134.89n 0.5 135.00n 0.0 139.89n 0.0 140.00n 0.5 144.89n 0.5 145.00n 0.5 149.89n 0.5 150.00n 0.5 154.89n 0.5 155.00n 0.0 159.89n 0.0 160.00n 0.5 164.89n 0.5 165.00n 0.0 169.89n 0.0 170.00n 0.5 174.89n 0.5 175.00n 0.5 179.89n 0.5 180.00n 0.5 184.89n 0.5 185.00n 0.5 189.89n 0.5 190.00n 0.0 194.89n 0.0 195.00n 0.0 199.89n 0.0 200.00n 0.0 204.89n 0.0 205.00n 0.0 209.89n 0.0 210.00n 0.0 214.89n 0.0 215.00n 0.5 219.89n 0.5 220.00n 0.0 224.89n 0.0 225.00n 0.0 229.89n 0.0 230.00n 0.0 234.89n 0.0 235.00n 0.0 239.89n 0.0 240.00n 0.5 244.89n 0.5 245.00n 0.0 249.89n 0.0)
Va15 A[15] 0 PWL(0.00n 0.0 4.89n 0.0 5.00n 0.5 9.89n 0.5 10.00n 0.0 14.89n 0.0 15.00n 0.0 19.89n 0.0 20.00n 0.0 24.89n 0.0 25.00n 0.5 29.89n 0.5 30.00n 0.5 34.89n 0.5 35.00n 0.0 39.89n 0.0 40.00n 0.5 44.89n 0.5 45.00n 0.5 49.89n 0.5 50.00n 0.5 54.89n 0.5 55.00n 0.0 59.89n 0.0 60.00n 0.5 64.89n 0.5 65.00n 0.0 69.89n 0.0 70.00n 0.0 74.89n 0.0 75.00n 0.0 79.89n 0.0 80.00n 0.5 84.89n 0.5 85.00n 0.5 89.89n 0.5 90.00n 0.0 94.89n 0.0 95.00n 0.0 99.89n 0.0 100.00n 0.0 104.89n 0.0 105.00n 0.5 109.89n 0.5 110.00n 0.0 114.89n 0.0 115.00n 0.0 119.89n 0.0 120.00n 0.0 124.89n 0.0 125.00n 0.0 129.89n 0.0 130.00n 0.5 134.89n 0.5 135.00n 0.5 139.89n 0.5 140.00n 0.0 144.89n 0.0 145.00n 0.5 149.89n 0.5 150.00n 0.5 154.89n 0.5 155.00n 0.5 159.89n 0.5 160.00n 0.0 164.89n 0.0 165.00n 0.5 169.89n 0.5 170.00n 0.0 174.89n 0.0 175.00n 0.5 179.89n 0.5 180.00n 0.5 184.89n 0.5 185.00n 0.5 189.89n 0.5 190.00n 0.5 194.89n 0.5 195.00n 0.0 199.89n 0.0 200.00n 0.0 204.89n 0.0 205.00n 0.0 209.89n 0.0 210.00n 0.0 214.89n 0.0 215.00n 0.0 219.89n 0.0 220.00n 0.5 224.89n 0.5 225.00n 0.0 229.89n 0.0 230.00n 0.0 234.89n 0.0 235.00n 0.0 239.89n 0.0 240.00n 0.0 244.89n 0.0 245.00n 0.5 249.89n 0.5)
Vb15 B[15] 0 PWL(0.00n 0.5 4.89n 0.5 5.00n 0.5 9.89n 0.5 10.00n 0.5 14.89n 0.5 15.00n 0.5 19.89n 0.5 20.00n 0.5 24.89n 0.5 25.00n 0.5 29.89n 0.5 30.00n 0.5 34.89n 0.5 35.00n 0.0 39.89n 0.0 40.00n 0.5 44.89n 0.5 45.00n 0.5 49.89n 0.5 50.00n 0.0 54.89n 0.0 55.00n 0.0 59.89n 0.0 60.00n 0.0 64.89n 0.0 65.00n 0.0 69.89n 0.0 70.00n 0.0 74.89n 0.0 75.00n 0.5 79.89n 0.5 80.00n 0.0 84.89n 0.0 85.00n 0.5 89.89n 0.5 90.00n 0.5 94.89n 0.5 95.00n 0.5 99.89n 0.5 100.00n 0.5 104.89n 0.5 105.00n 0.0 109.89n 0.0 110.00n 0.5 114.89n 0.5 115.00n 0.5 119.89n 0.5 120.00n 0.5 124.89n 0.5 125.00n 0.0 129.89n 0.0 130.00n 0.5 134.89n 0.5 135.00n 0.0 139.89n 0.0 140.00n 0.0 144.89n 0.0 145.00n 0.5 149.89n 0.5 150.00n 0.0 154.89n 0.0 155.00n 0.5 159.89n 0.5 160.00n 0.5 164.89n 0.5 165.00n 0.0 169.89n 0.0 170.00n 0.0 174.89n 0.0 175.00n 0.5 179.89n 0.5 180.00n 0.0 184.89n 0.0 185.00n 0.0 189.89n 0.0 190.00n 0.5 194.89n 0.5 195.00n 0.5 199.89n 0.5 200.00n 0.5 204.89n 0.5 205.00n 0.0 209.89n 0.0 210.00n 0.5 214.89n 0.5 215.00n 0.5 219.89n 0.5 220.00n 0.0 224.89n 0.0 225.00n 0.5 229.89n 0.5 230.00n 0.5 234.89n 0.5 235.00n 0.0 239.89n 0.0 240.00n 0.0 244.89n 0.0 245.00n 0.0 249.89n 0.0)
Va16 A[16] 0 PWL(0.00n 0.5 4.89n 0.5 5.00n 0.5 9.89n 0.5 10.00n 0.5 14.89n 0.5 15.00n 0.5 19.89n 0.5 20.00n 0.5 24.89n 0.5 25.00n 0.5 29.89n 0.5 30.00n 0.5 34.89n 0.5 35.00n 0.5 39.89n 0.5 40.00n 0.0 44.89n 0.0 45.00n 0.5 49.89n 0.5 50.00n 0.5 54.89n 0.5 55.00n 0.0 59.89n 0.0 60.00n 0.0 64.89n 0.0 65.00n 0.0 69.89n 0.0 70.00n 0.0 74.89n 0.0 75.00n 0.0 79.89n 0.0 80.00n 0.5 84.89n 0.5 85.00n 0.0 89.89n 0.0 90.00n 0.5 94.89n 0.5 95.00n 0.5 99.89n 0.5 100.00n 0.5 104.89n 0.5 105.00n 0.5 109.89n 0.5 110.00n 0.0 114.89n 0.0 115.00n 0.5 119.89n 0.5 120.00n 0.5 124.89n 0.5 125.00n 0.5 129.89n 0.5 130.00n 0.0 134.89n 0.0 135.00n 0.5 139.89n 0.5 140.00n 0.0 144.89n 0.0 145.00n 0.0 149.89n 0.0 150.00n 0.5 154.89n 0.5 155.00n 0.0 159.89n 0.0 160.00n 0.5 164.89n 0.5 165.00n 0.5 169.89n 0.5 170.00n 0.0 174.89n 0.0 175.00n 0.0 179.89n 0.0 180.00n 0.5 184.89n 0.5 185.00n 0.0 189.89n 0.0 190.00n 0.0 194.89n 0.0 195.00n 0.5 199.89n 0.5 200.00n 0.5 204.89n 0.5 205.00n 0.5 209.89n 0.5 210.00n 0.0 214.89n 0.0 215.00n 0.5 219.89n 0.5 220.00n 0.5 224.89n 0.5 225.00n 0.0 229.89n 0.0 230.00n 0.5 234.89n 0.5 235.00n 0.5 239.89n 0.5 240.00n 0.0 244.89n 0.0 245.00n 0.0 249.89n 0.0)
Vb16 B[16] 0 PWL(0.00n 0.0 4.89n 0.0 5.00n 0.5 9.89n 0.5 10.00n 0.0 14.89n 0.0 15.00n 0.0 19.89n 0.0 20.00n 0.0 24.89n 0.0 25.00n 0.5 29.89n 0.5 30.00n 0.5 34.89n 0.5 35.00n 0.0 39.89n 0.0 40.00n 0.5 44.89n 0.5 45.00n 0.5 49.89n 0.5 50.00n 0.5 54.89n 0.5 55.00n 0.0 59.89n 0.0 60.00n 0.5 64.89n 0.5 65.00n 0.0 69.89n 0.0 70.00n 0.0 74.89n 0.0 75.00n 0.0 79.89n 0.0 80.00n 0.5 84.89n 0.5 85.00n 0.5 89.89n 0.5 90.00n 0.0 94.89n 0.0 95.00n 0.0 99.89n 0.0 100.00n 0.0 104.89n 0.0 105.00n 0.5 109.89n 0.5 110.00n 0.0 114.89n 0.0 115.00n 0.0 119.89n 0.0 120.00n 0.0 124.89n 0.0 125.00n 0.0 129.89n 0.0 130.00n 0.5 134.89n 0.5 135.00n 0.5 139.89n 0.5 140.00n 0.0 144.89n 0.0 145.00n 0.5 149.89n 0.5 150.00n 0.5 154.89n 0.5 155.00n 0.5 159.89n 0.5 160.00n 0.0 164.89n 0.0 165.00n 0.5 169.89n 0.5 170.00n 0.0 174.89n 0.0 175.00n 0.5 179.89n 0.5 180.00n 0.5 184.89n 0.5 185.00n 0.5 189.89n 0.5 190.00n 0.5 194.89n 0.5 195.00n 0.0 199.89n 0.0 200.00n 0.0 204.89n 0.0 205.00n 0.0 209.89n 0.0 210.00n 0.0 214.89n 0.0 215.00n 0.0 219.89n 0.0 220.00n 0.5 224.89n 0.5 225.00n 0.0 229.89n 0.0 230.00n 0.0 234.89n 0.0 235.00n 0.0 239.89n 0.0 240.00n 0.0 244.89n 0.0 245.00n 0.5 249.89n 0.5)
Va17 A[17] 0 PWL(0.00n 0.0 4.89n 0.0 5.00n 0.0 9.89n 0.0 10.00n 0.5 14.89n 0.5 15.00n 0.0 19.89n 0.0 20.00n 0.0 24.89n 0.0 25.00n 0.0 29.89n 0.0 30.00n 0.5 34.89n 0.5 35.00n 0.5 39.89n 0.5 40.00n 0.0 44.89n 0.0 45.00n 0.5 49.89n 0.5 50.00n 0.5 54.89n 0.5 55.00n 0.5 59.89n 0.5 60.00n 0.0 64.89n 0.0 65.00n 0.5 69.89n 0.5 70.00n 0.0 74.89n 0.0 75.00n 0.0 79.89n 0.0 80.00n 0.0 84.89n 0.0 85.00n 0.5 89.89n 0.5 90.00n 0.5 94.89n 0.5 95.00n 0.0 99.89n 0.0 100.00n 0.0 104.89n 0.0 105.00n 0.0 109.89n 0.0 110.00n 0.5 114.89n 0.5 115.00n 0.0 119.89n 0.0 120.00n 0.0 124.89n 0.0 125.00n 0.0 129.89n 0.0 130.00n 0.0 134.89n 0.0 135.00n 0.5 139.89n 0.5 140.00n 0.5 144.89n 0.5 145.00n 0.0 149.89n 0.0 150.00n 0.5 154.89n 0.5 155.00n 0.5 159.89n 0.5 160.00n 0.5 164.89n 0.5 165.00n 0.0 169.89n 0.0 170.00n 0.5 174.89n 0.5 175.00n 0.0 179.89n 0.0 180.00n 0.5 184.89n 0.5 185.00n 0.5 189.89n 0.5 190.00n 0.5 194.89n 0.5 195.00n 0.5 199.89n 0.5 200.00n 0.0 204.89n 0.0 205.00n 0.0 209.89n 0.0 210.00n 0.0 214.89n 0.0 215.00n 0.0 219.89n 0.0 220.00n 0.0 224.89n 0.0 225.00n 0.5 229.89n 0.5 230.00n 0.0 234.89n 0.0 235.00n 0.0 239.89n 0.0 240.00n 0.0 244.89n 0.0 245.00n 0.0 249.89n 0.0)
Vb17 B[17] 0 PWL(0.00n 0.5 4.89n 0.5 5.00n 0.5 9.89n 0.5 10.00n 0.5 14.89n 0.5 15.00n 0.5 19.89n 0.5 20.00n 0.5 24.89n 0.5 25.00n 0.5 29.89n 0.5 30.00n 0.5 34.89n 0.5 35.00n 0.5 39.89n 0.5 40.00n 0.0 44.89n 0.0 45.00n 0.5 49.89n 0.5 50.00n 0.5 54.89n 0.5 55.00n 0.0 59.89n 0.0 60.00n 0.0 64.89n 0.0 65.00n 0.0 69.89n 0.0 70.00n 0.0 74.89n 0.0 75.00n 0.0 79.89n 0.0 80.00n 0.5 84.89n 0.5 85.00n 0.0 89.89n 0.0 90.00n 0.5 94.89n 0.5 95.00n 0.5 99.89n 0.5 100.00n 0.5 104.89n 0.5 105.00n 0.5 109.89n 0.5 110.00n 0.0 114.89n 0.0 115.00n 0.5 119.89n 0.5 120.00n 0.5 124.89n 0.5 125.00n 0.5 129.89n 0.5 130.00n 0.0 134.89n 0.0 135.00n 0.5 139.89n 0.5 140.00n 0.0 144.89n 0.0 145.00n 0.0 149.89n 0.0 150.00n 0.5 154.89n 0.5 155.00n 0.0 159.89n 0.0 160.00n 0.5 164.89n 0.5 165.00n 0.5 169.89n 0.5 170.00n 0.0 174.89n 0.0 175.00n 0.0 179.89n 0.0 180.00n 0.5 184.89n 0.5 185.00n 0.0 189.89n 0.0 190.00n 0.0 194.89n 0.0 195.00n 0.5 199.89n 0.5 200.00n 0.5 204.89n 0.5 205.00n 0.5 209.89n 0.5 210.00n 0.0 214.89n 0.0 215.00n 0.5 219.89n 0.5 220.00n 0.5 224.89n 0.5 225.00n 0.0 229.89n 0.0 230.00n 0.5 234.89n 0.5 235.00n 0.5 239.89n 0.5 240.00n 0.0 244.89n 0.0 245.00n 0.0 249.89n 0.0)
Va18 A[18] 0 PWL(0.00n 0.5 4.89n 0.5 5.00n 0.5 9.89n 0.5 10.00n 0.5 14.89n 0.5 15.00n 0.5 19.89n 0.5 20.00n 0.5 24.89n 0.5 25.00n 0.5 29.89n 0.5 30.00n 0.5 34.89n 0.5 35.00n 0.5 39.89n 0.5 40.00n 0.5 44.89n 0.5 45.00n 0.0 49.89n 0.0 50.00n 0.5 54.89n 0.5 55.00n 0.5 59.89n 0.5 60.00n 0.0 64.89n 0.0 65.00n 0.0 69.89n 0.0 70.00n 0.0 74.89n 0.0 75.00n 0.0 79.89n 0.0 80.00n 0.0 84.89n 0.0 85.00n 0.5 89.89n 0.5 90.00n 0.0 94.89n 0.0 95.00n 0.5 99.89n 0.5 100.00n 0.5 104.89n 0.5 105.00n 0.5 109.89n 0.5 110.00n 0.5 114.89n 0.5 115.00n 0.0 119.89n 0.0 120.00n 0.5 124.89n 0.5 125.00n 0.5 129.89n 0.5 130.00n 0.5 134.89n 0.5 135.00n 0.0 139.89n 0.0 140.00n 0.5 144.89n 0.5 145.00n 0.0 149.89n 0.0 150.00n 0.0 154.89n 0.0 155.00n 0.5 159.89n 0.5 160.00n 0.0 164.89n 0.0 165.00n 0.5 169.89n 0.5 170.00n 0.5 174.89n 0.5 175.00n 0.0 179.89n 0.0 180.00n 0.0 184.89n 0.0 185.00n 0.5 189.89n 0.5 190.00n 0.0 194.89n 0.0 195.00n 0.0 199.89n 0.0 200.00n 0.5 204.89n 0.5 205.00n 0.5 209.89n 0.5 210.00n 0.5 214.89n 0.5 215.00n 0.0 219.89n 0.0 220.00n 0.5 224.89n 0.5 225.00n 0.5 229.89n 0.5 230.00n 0.0 234.89n 0.0 235.00n 0.5 239.89n 0.5 240.00n 0.5 244.89n 0.5 245.00n 0.0 249.89n 0.0)
Vb18 B[18] 0 PWL(0.00n 0.0 4.89n 0.0 5.00n 0.0 9.89n 0.0 10.00n 0.5 14.89n 0.5 15.00n 0.0 19.89n 0.0 20.00n 0.0 24.89n 0.0 25.00n 0.0 29.89n 0.0 30.00n 0.5 34.89n 0.5 35.00n 0.5 39.89n 0.5 40.00n 0.0 44.89n 0.0 45.00n 0.5 49.89n 0.5 50.00n 0.5 54.89n 0.5 55.00n 0.5 59.89n 0.5 60.00n 0.0 64.89n 0.0 65.00n 0.5 69.89n 0.5 70.00n 0.0 74.89n 0.0 75.00n 0.0 79.89n 0.0 80.00n 0.0 84.89n 0.0 85.00n 0.5 89.89n 0.5 90.00n 0.5 94.89n 0.5 95.00n 0.0 99.89n 0.0 100.00n 0.0 104.89n 0.0 105.00n 0.0 109.89n 0.0 110.00n 0.5 114.89n 0.5 115.00n 0.0 119.89n 0.0 120.00n 0.0 124.89n 0.0 125.00n 0.0 129.89n 0.0 130.00n 0.0 134.89n 0.0 135.00n 0.5 139.89n 0.5 140.00n 0.5 144.89n 0.5 145.00n 0.0 149.89n 0.0 150.00n 0.5 154.89n 0.5 155.00n 0.5 159.89n 0.5 160.00n 0.5 164.89n 0.5 165.00n 0.0 169.89n 0.0 170.00n 0.5 174.89n 0.5 175.00n 0.0 179.89n 0.0 180.00n 0.5 184.89n 0.5 185.00n 0.5 189.89n 0.5 190.00n 0.5 194.89n 0.5 195.00n 0.5 199.89n 0.5 200.00n 0.0 204.89n 0.0 205.00n 0.0 209.89n 0.0 210.00n 0.0 214.89n 0.0 215.00n 0.0 219.89n 0.0 220.00n 0.0 224.89n 0.0 225.00n 0.5 229.89n 0.5 230.00n 0.0 234.89n 0.0 235.00n 0.0 239.89n 0.0 240.00n 0.0 244.89n 0.0 245.00n 0.0 249.89n 0.0)
Va19 A[19] 0 PWL(0.00n 0.5 4.89n 0.5 5.00n 0.0 9.89n 0.0 10.00n 0.0 14.89n 0.0 15.00n 0.5 19.89n 0.5 20.00n 0.0 24.89n 0.0 25.00n 0.0 29.89n 0.0 30.00n 0.0 34.89n 0.0 35.00n 0.5 39.89n 0.5 40.00n 0.5 44.89n 0.5 45.00n 0.0 49.89n 0.0 50.00n 0.5 54.89n 0.5 55.00n 0.5 59.89n 0.5 60.00n 0.5 64.89n 0.5 65.00n 0.0 69.89n 0.0 70.00n 0.5 74.89n 0.5 75.00n 0.0 79.89n 0.0 80.00n 0.0 84.89n 0.0 85.00n 0.0 89.89n 0.0 90.00n 0.5 94.89n 0.5 95.00n 0.5 99.89n 0.5 100.00n 0.0 104.89n 0.0 105.00n 0.0 109.89n 0.0 110.00n 0.0 114.89n 0.0 115.00n 0.5 119.89n 0.5 120.00n 0.0 124.89n 0.0 125.00n 0.0 129.89n 0.0 130.00n 0.0 134.89n 0.0 135.00n 0.0 139.89n 0.0 140.00n 0.5 144.89n 0.5 145.00n 0.5 149.89n 0.5 150.00n 0.0 154.89n 0.0 155.00n 0.5 159.89n 0.5 160.00n 0.5 164.89n 0.5 165.00n 0.5 169.89n 0.5 170.00n 0.0 174.89n 0.0 175.00n 0.5 179.89n 0.5 180.00n 0.0 184.89n 0.0 185.00n 0.5 189.89n 0.5 190.00n 0.5 194.89n 0.5 195.00n 0.5 199.89n 0.5 200.00n 0.5 204.89n 0.5 205.00n 0.0 209.89n 0.0 210.00n 0.0 214.89n 0.0 215.00n 0.0 219.89n 0.0 220.00n 0.0 224.89n 0.0 225.00n 0.0 229.89n 0.0 230.00n 0.5 234.89n 0.5 235.00n 0.0 239.89n 0.0 240.00n 0.0 244.89n 0.0 245.00n 0.0 249.89n 0.0)
Vb19 B[19] 0 PWL(0.00n 0.5 4.89n 0.5 5.00n 0.5 9.89n 0.5 10.00n 0.5 14.89n 0.5 15.00n 0.5 19.89n 0.5 20.00n 0.5 24.89n 0.5 25.00n 0.5 29.89n 0.5 30.00n 0.5 34.89n 0.5 35.00n 0.5 39.89n 0.5 40.00n 0.5 44.89n 0.5 45.00n 0.0 49.89n 0.0 50.00n 0.5 54.89n 0.5 55.00n 0.5 59.89n 0.5 60.00n 0.0 64.89n 0.0 65.00n 0.0 69.89n 0.0 70.00n 0.0 74.89n 0.0 75.00n 0.0 79.89n 0.0 80.00n 0.0 84.89n 0.0 85.00n 0.5 89.89n 0.5 90.00n 0.0 94.89n 0.0 95.00n 0.5 99.89n 0.5 100.00n 0.5 104.89n 0.5 105.00n 0.5 109.89n 0.5 110.00n 0.5 114.89n 0.5 115.00n 0.0 119.89n 0.0 120.00n 0.5 124.89n 0.5 125.00n 0.5 129.89n 0.5 130.00n 0.5 134.89n 0.5 135.00n 0.0 139.89n 0.0 140.00n 0.5 144.89n 0.5 145.00n 0.0 149.89n 0.0 150.00n 0.0 154.89n 0.0 155.00n 0.5 159.89n 0.5 160.00n 0.0 164.89n 0.0 165.00n 0.5 169.89n 0.5 170.00n 0.5 174.89n 0.5 175.00n 0.0 179.89n 0.0 180.00n 0.0 184.89n 0.0 185.00n 0.5 189.89n 0.5 190.00n 0.0 194.89n 0.0 195.00n 0.0 199.89n 0.0 200.00n 0.5 204.89n 0.5 205.00n 0.5 209.89n 0.5 210.00n 0.5 214.89n 0.5 215.00n 0.0 219.89n 0.0 220.00n 0.5 224.89n 0.5 225.00n 0.5 229.89n 0.5 230.00n 0.0 234.89n 0.0 235.00n 0.5 239.89n 0.5 240.00n 0.5 244.89n 0.5 245.00n 0.0 249.89n 0.0)
Va20 A[20] 0 PWL(0.00n 0.5 4.89n 0.5 5.00n 0.5 9.89n 0.5 10.00n 0.5 14.89n 0.5 15.00n 0.5 19.89n 0.5 20.00n 0.5 24.89n 0.5 25.00n 0.5 29.89n 0.5 30.00n 0.5 34.89n 0.5 35.00n 0.5 39.89n 0.5 40.00n 0.5 44.89n 0.5 45.00n 0.5 49.89n 0.5 50.00n 0.0 54.89n 0.0 55.00n 0.5 59.89n 0.5 60.00n 0.5 64.89n 0.5 65.00n 0.0 69.89n 0.0 70.00n 0.0 74.89n 0.0 75.00n 0.0 79.89n 0.0 80.00n 0.0 84.89n 0.0 85.00n 0.0 89.89n 0.0 90.00n 0.5 94.89n 0.5 95.00n 0.0 99.89n 0.0 100.00n 0.5 104.89n 0.5 105.00n 0.5 109.89n 0.5 110.00n 0.5 114.89n 0.5 115.00n 0.5 119.89n 0.5 120.00n 0.0 124.89n 0.0 125.00n 0.5 129.89n 0.5 130.00n 0.5 134.89n 0.5 135.00n 0.5 139.89n 0.5 140.00n 0.0 144.89n 0.0 145.00n 0.5 149.89n 0.5 150.00n 0.0 154.89n 0.0 155.00n 0.0 159.89n 0.0 160.00n 0.5 164.89n 0.5 165.00n 0.0 169.89n 0.0 170.00n 0.5 174.89n 0.5 175.00n 0.5 179.89n 0.5 180.00n 0.0 184.89n 0.0 185.00n 0.0 189.89n 0.0 190.00n 0.5 194.89n 0.5 195.00n 0.0 199.89n 0.0 200.00n 0.0 204.89n 0.0 205.00n 0.5 209.89n 0.5 210.00n 0.5 214.89n 0.5 215.00n 0.5 219.89n 0.5 220.00n 0.0 224.89n 0.0 225.00n 0.5 229.89n 0.5 230.00n 0.5 234.89n 0.5 235.00n 0.0 239.89n 0.0 240.00n 0.5 244.89n 0.5 245.00n 0.5 249.89n 0.5)
Vb20 B[20] 0 PWL(0.00n 0.5 4.89n 0.5 5.00n 0.0 9.89n 0.0 10.00n 0.0 14.89n 0.0 15.00n 0.5 19.89n 0.5 20.00n 0.0 24.89n 0.0 25.00n 0.0 29.89n 0.0 30.00n 0.0 34.89n 0.0 35.00n 0.5 39.89n 0.5 40.00n 0.5 44.89n 0.5 45.00n 0.0 49.89n 0.0 50.00n 0.5 54.89n 0.5 55.00n 0.5 59.89n 0.5 60.00n 0.5 64.89n 0.5 65.00n 0.0 69.89n 0.0 70.00n 0.5 74.89n 0.5 75.00n 0.0 79.89n 0.0 80.00n 0.0 84.89n 0.0 85.00n 0.0 89.89n 0.0 90.00n 0.5 94.89n 0.5 95.00n 0.5 99.89n 0.5 100.00n 0.0 104.89n 0.0 105.00n 0.0 109.89n 0.0 110.00n 0.0 114.89n 0.0 115.00n 0.5 119.89n 0.5 120.00n 0.0 124.89n 0.0 125.00n 0.0 129.89n 0.0 130.00n 0.0 134.89n 0.0 135.00n 0.0 139.89n 0.0 140.00n 0.5 144.89n 0.5 145.00n 0.5 149.89n 0.5 150.00n 0.0 154.89n 0.0 155.00n 0.5 159.89n 0.5 160.00n 0.5 164.89n 0.5 165.00n 0.5 169.89n 0.5 170.00n 0.0 174.89n 0.0 175.00n 0.5 179.89n 0.5 180.00n 0.0 184.89n 0.0 185.00n 0.5 189.89n 0.5 190.00n 0.5 194.89n 0.5 195.00n 0.5 199.89n 0.5 200.00n 0.5 204.89n 0.5 205.00n 0.0 209.89n 0.0 210.00n 0.0 214.89n 0.0 215.00n 0.0 219.89n 0.0 220.00n 0.0 224.89n 0.0 225.00n 0.0 229.89n 0.0 230.00n 0.5 234.89n 0.5 235.00n 0.0 239.89n 0.0 240.00n 0.0 244.89n 0.0 245.00n 0.0 249.89n 0.0)
Va21 A[21] 0 PWL(0.00n 0.5 4.89n 0.5 5.00n 0.5 9.89n 0.5 10.00n 0.0 14.89n 0.0 15.00n 0.0 19.89n 0.0 20.00n 0.5 24.89n 0.5 25.00n 0.0 29.89n 0.0 30.00n 0.0 34.89n 0.0 35.00n 0.0 39.89n 0.0 40.00n 0.5 44.89n 0.5 45.00n 0.5 49.89n 0.5 50.00n 0.0 54.89n 0.0 55.00n 0.5 59.89n 0.5 60.00n 0.5 64.89n 0.5 65.00n 0.5 69.89n 0.5 70.00n 0.0 74.89n 0.0 75.00n 0.5 79.89n 0.5 80.00n 0.0 84.89n 0.0 85.00n 0.0 89.89n 0.0 90.00n 0.0 94.89n 0.0 95.00n 0.5 99.89n 0.5 100.00n 0.5 104.89n 0.5 105.00n 0.0 109.89n 0.0 110.00n 0.0 114.89n 0.0 115.00n 0.0 119.89n 0.0 120.00n 0.5 124.89n 0.5 125.00n 0.0 129.89n 0.0 130.00n 0.0 134.89n 0.0 135.00n 0.0 139.89n 0.0 140.00n 0.0 144.89n 0.0 145.00n 0.5 149.89n 0.5 150.00n 0.5 154.89n 0.5 155.00n 0.0 159.89n 0.0 160.00n 0.5 164.89n 0.5 165.00n 0.5 169.89n 0.5 170.00n 0.5 174.89n 0.5 175.00n 0.0 179.89n 0.0 180.00n 0.5 184.89n 0.5 185.00n 0.0 189.89n 0.0 190.00n 0.5 194.89n 0.5 195.00n 0.5 199.89n 0.5 200.00n 0.5 204.89n 0.5 205.00n 0.5 209.89n 0.5 210.00n 0.0 214.89n 0.0 215.00n 0.0 219.89n 0.0 220.00n 0.0 224.89n 0.0 225.00n 0.0 229.89n 0.0 230.00n 0.0 234.89n 0.0 235.00n 0.5 239.89n 0.5 240.00n 0.0 244.89n 0.0 245.00n 0.0 249.89n 0.0)
Vb21 B[21] 0 PWL(0.00n 0.5 4.89n 0.5 5.00n 0.5 9.89n 0.5 10.00n 0.5 14.89n 0.5 15.00n 0.5 19.89n 0.5 20.00n 0.5 24.89n 0.5 25.00n 0.5 29.89n 0.5 30.00n 0.5 34.89n 0.5 35.00n 0.5 39.89n 0.5 40.00n 0.5 44.89n 0.5 45.00n 0.5 49.89n 0.5 50.00n 0.0 54.89n 0.0 55.00n 0.5 59.89n 0.5 60.00n 0.5 64.89n 0.5 65.00n 0.0 69.89n 0.0 70.00n 0.0 74.89n 0.0 75.00n 0.0 79.89n 0.0 80.00n 0.0 84.89n 0.0 85.00n 0.0 89.89n 0.0 90.00n 0.5 94.89n 0.5 95.00n 0.0 99.89n 0.0 100.00n 0.5 104.89n 0.5 105.00n 0.5 109.89n 0.5 110.00n 0.5 114.89n 0.5 115.00n 0.5 119.89n 0.5 120.00n 0.0 124.89n 0.0 125.00n 0.5 129.89n 0.5 130.00n 0.5 134.89n 0.5 135.00n 0.5 139.89n 0.5 140.00n 0.0 144.89n 0.0 145.00n 0.5 149.89n 0.5 150.00n 0.0 154.89n 0.0 155.00n 0.0 159.89n 0.0 160.00n 0.5 164.89n 0.5 165.00n 0.0 169.89n 0.0 170.00n 0.5 174.89n 0.5 175.00n 0.5 179.89n 0.5 180.00n 0.0 184.89n 0.0 185.00n 0.0 189.89n 0.0 190.00n 0.5 194.89n 0.5 195.00n 0.0 199.89n 0.0 200.00n 0.0 204.89n 0.0 205.00n 0.5 209.89n 0.5 210.00n 0.5 214.89n 0.5 215.00n 0.5 219.89n 0.5 220.00n 0.0 224.89n 0.0 225.00n 0.5 229.89n 0.5 230.00n 0.5 234.89n 0.5 235.00n 0.0 239.89n 0.0 240.00n 0.5 244.89n 0.5 245.00n 0.5 249.89n 0.5)
Va22 A[22] 0 PWL(0.00n 0.5 4.89n 0.5 5.00n 0.5 9.89n 0.5 10.00n 0.5 14.89n 0.5 15.00n 0.5 19.89n 0.5 20.00n 0.5 24.89n 0.5 25.00n 0.5 29.89n 0.5 30.00n 0.5 34.89n 0.5 35.00n 0.5 39.89n 0.5 40.00n 0.5 44.89n 0.5 45.00n 0.5 49.89n 0.5 50.00n 0.5 54.89n 0.5 55.00n 0.0 59.89n 0.0 60.00n 0.5 64.89n 0.5 65.00n 0.5 69.89n 0.5 70.00n 0.0 74.89n 0.0 75.00n 0.0 79.89n 0.0 80.00n 0.0 84.89n 0.0 85.00n 0.0 89.89n 0.0 90.00n 0.0 94.89n 0.0 95.00n 0.5 99.89n 0.5 100.00n 0.0 104.89n 0.0 105.00n 0.5 109.89n 0.5 110.00n 0.5 114.89n 0.5 115.00n 0.5 119.89n 0.5 120.00n 0.5 124.89n 0.5 125.00n 0.0 129.89n 0.0 130.00n 0.5 134.89n 0.5 135.00n 0.5 139.89n 0.5 140.00n 0.5 144.89n 0.5 145.00n 0.0 149.89n 0.0 150.00n 0.5 154.89n 0.5 155.00n 0.0 159.89n 0.0 160.00n 0.0 164.89n 0.0 165.00n 0.5 169.89n 0.5 170.00n 0.0 174.89n 0.0 175.00n 0.5 179.89n 0.5 180.00n 0.5 184.89n 0.5 185.00n 0.0 189.89n 0.0 190.00n 0.0 194.89n 0.0 195.00n 0.5 199.89n 0.5 200.00n 0.0 204.89n 0.0 205.00n 0.0 209.89n 0.0 210.00n 0.5 214.89n 0.5 215.00n 0.5 219.89n 0.5 220.00n 0.5 224.89n 0.5 225.00n 0.0 229.89n 0.0 230.00n 0.5 234.89n 0.5 235.00n 0.5 239.89n 0.5 240.00n 0.0 244.89n 0.0 245.00n 0.5 249.89n 0.5)
Vb22 B[22] 0 PWL(0.00n 0.5 4.89n 0.5 5.00n 0.5 9.89n 0.5 10.00n 0.0 14.89n 0.0 15.00n 0.0 19.89n 0.0 20.00n 0.5 24.89n 0.5 25.00n 0.0 29.89n 0.0 30.00n 0.0 34.89n 0.0 35.00n 0.0 39.89n 0.0 40.00n 0.5 44.89n 0.5 45.00n 0.5 49.89n 0.5 50.00n 0.0 54.89n 0.0 55.00n 0.5 59.89n 0.5 60.00n 0.5 64.89n 0.5 65.00n 0.5 69.89n 0.5 70.00n 0.0 74.89n 0.0 75.00n 0.5 79.89n 0.5 80.00n 0.0 84.89n 0.0 85.00n 0.0 89.89n 0.0 90.00n 0.0 94.89n 0.0 95.00n 0.5 99.89n 0.5 100.00n 0.5 104.89n 0.5 105.00n 0.0 109.89n 0.0 110.00n 0.0 114.89n 0.0 115.00n 0.0 119.89n 0.0 120.00n 0.5 124.89n 0.5 125.00n 0.0 129.89n 0.0 130.00n 0.0 134.89n 0.0 135.00n 0.0 139.89n 0.0 140.00n 0.0 144.89n 0.0 145.00n 0.5 149.89n 0.5 150.00n 0.5 154.89n 0.5 155.00n 0.0 159.89n 0.0 160.00n 0.5 164.89n 0.5 165.00n 0.5 169.89n 0.5 170.00n 0.5 174.89n 0.5 175.00n 0.0 179.89n 0.0 180.00n 0.5 184.89n 0.5 185.00n 0.0 189.89n 0.0 190.00n 0.5 194.89n 0.5 195.00n 0.5 199.89n 0.5 200.00n 0.5 204.89n 0.5 205.00n 0.5 209.89n 0.5 210.00n 0.0 214.89n 0.0 215.00n 0.0 219.89n 0.0 220.00n 0.0 224.89n 0.0 225.00n 0.0 229.89n 0.0 230.00n 0.0 234.89n 0.0 235.00n 0.5 239.89n 0.5 240.00n 0.0 244.89n 0.0 245.00n 0.0 249.89n 0.0)
Va23 A[23] 0 PWL(0.00n 0.5 4.89n 0.5 5.00n 0.5 9.89n 0.5 10.00n 0.5 14.89n 0.5 15.00n 0.0 19.89n 0.0 20.00n 0.0 24.89n 0.0 25.00n 0.5 29.89n 0.5 30.00n 0.0 34.89n 0.0 35.00n 0.0 39.89n 0.0 40.00n 0.0 44.89n 0.0 45.00n 0.5 49.89n 0.5 50.00n 0.5 54.89n 0.5 55.00n 0.0 59.89n 0.0 60.00n 0.5 64.89n 0.5 65.00n 0.5 69.89n 0.5 70.00n 0.5 74.89n 0.5 75.00n 0.0 79.89n 0.0 80.00n 0.5 84.89n 0.5 85.00n 0.0 89.89n 0.0 90.00n 0.0 94.89n 0.0 95.00n 0.0 99.89n 0.0 100.00n 0.5 104.89n 0.5 105.00n 0.5 109.89n 0.5 110.00n 0.0 114.89n 0.0 115.00n 0.0 119.89n 0.0 120.00n 0.0 124.89n 0.0 125.00n 0.5 129.89n 0.5 130.00n 0.0 134.89n 0.0 135.00n 0.0 139.89n 0.0 140.00n 0.0 144.89n 0.0 145.00n 0.0 149.89n 0.0 150.00n 0.5 154.89n 0.5 155.00n 0.5 159.89n 0.5 160.00n 0.0 164.89n 0.0 165.00n 0.5 169.89n 0.5 170.00n 0.5 174.89n 0.5 175.00n 0.5 179.89n 0.5 180.00n 0.0 184.89n 0.0 185.00n 0.5 189.89n 0.5 190.00n 0.0 194.89n 0.0 195.00n 0.5 199.89n 0.5 200.00n 0.5 204.89n 0.5 205.00n 0.5 209.89n 0.5 210.00n 0.5 214.89n 0.5 215.00n 0.0 219.89n 0.0 220.00n 0.0 224.89n 0.0 225.00n 0.0 229.89n 0.0 230.00n 0.0 234.89n 0.0 235.00n 0.0 239.89n 0.0 240.00n 0.5 244.89n 0.5 245.00n 0.0 249.89n 0.0)
Vb23 B[23] 0 PWL(0.00n 0.5 4.89n 0.5 5.00n 0.5 9.89n 0.5 10.00n 0.5 14.89n 0.5 15.00n 0.5 19.89n 0.5 20.00n 0.5 24.89n 0.5 25.00n 0.5 29.89n 0.5 30.00n 0.5 34.89n 0.5 35.00n 0.5 39.89n 0.5 40.00n 0.5 44.89n 0.5 45.00n 0.5 49.89n 0.5 50.00n 0.5 54.89n 0.5 55.00n 0.0 59.89n 0.0 60.00n 0.5 64.89n 0.5 65.00n 0.5 69.89n 0.5 70.00n 0.0 74.89n 0.0 75.00n 0.0 79.89n 0.0 80.00n 0.0 84.89n 0.0 85.00n 0.0 89.89n 0.0 90.00n 0.0 94.89n 0.0 95.00n 0.5 99.89n 0.5 100.00n 0.0 104.89n 0.0 105.00n 0.5 109.89n 0.5 110.00n 0.5 114.89n 0.5 115.00n 0.5 119.89n 0.5 120.00n 0.5 124.89n 0.5 125.00n 0.0 129.89n 0.0 130.00n 0.5 134.89n 0.5 135.00n 0.5 139.89n 0.5 140.00n 0.5 144.89n 0.5 145.00n 0.0 149.89n 0.0 150.00n 0.5 154.89n 0.5 155.00n 0.0 159.89n 0.0 160.00n 0.0 164.89n 0.0 165.00n 0.5 169.89n 0.5 170.00n 0.0 174.89n 0.0 175.00n 0.5 179.89n 0.5 180.00n 0.5 184.89n 0.5 185.00n 0.0 189.89n 0.0 190.00n 0.0 194.89n 0.0 195.00n 0.5 199.89n 0.5 200.00n 0.0 204.89n 0.0 205.00n 0.0 209.89n 0.0 210.00n 0.5 214.89n 0.5 215.00n 0.5 219.89n 0.5 220.00n 0.5 224.89n 0.5 225.00n 0.0 229.89n 0.0 230.00n 0.5 234.89n 0.5 235.00n 0.5 239.89n 0.5 240.00n 0.0 244.89n 0.0 245.00n 0.5 249.89n 0.5)
Va24 A[24] 0 PWL(0.00n 0.5 4.89n 0.5 5.00n 0.5 9.89n 0.5 10.00n 0.5 14.89n 0.5 15.00n 0.5 19.89n 0.5 20.00n 0.5 24.89n 0.5 25.00n 0.5 29.89n 0.5 30.00n 0.5 34.89n 0.5 35.00n 0.5 39.89n 0.5 40.00n 0.5 44.89n 0.5 45.00n 0.5 49.89n 0.5 50.00n 0.5 54.89n 0.5 55.00n 0.5 59.89n 0.5 60.00n 0.0 64.89n 0.0 65.00n 0.5 69.89n 0.5 70.00n 0.5 74.89n 0.5 75.00n 0.0 79.89n 0.0 80.00n 0.0 84.89n 0.0 85.00n 0.0 89.89n 0.0 90.00n 0.0 94.89n 0.0 95.00n 0.0 99.89n 0.0 100.00n 0.5 104.89n 0.5 105.00n 0.0 109.89n 0.0 110.00n 0.5 114.89n 0.5 115.00n 0.5 119.89n 0.5 120.00n 0.5 124.89n 0.5 125.00n 0.5 129.89n 0.5 130.00n 0.0 134.89n 0.0 135.00n 0.5 139.89n 0.5 140.00n 0.5 144.89n 0.5 145.00n 0.5 149.89n 0.5 150.00n 0.0 154.89n 0.0 155.00n 0.5 159.89n 0.5 160.00n 0.0 164.89n 0.0 165.00n 0.0 169.89n 0.0 170.00n 0.5 174.89n 0.5 175.00n 0.0 179.89n 0.0 180.00n 0.5 184.89n 0.5 185.00n 0.5 189.89n 0.5 190.00n 0.0 194.89n 0.0 195.00n 0.0 199.89n 0.0 200.00n 0.5 204.89n 0.5 205.00n 0.0 209.89n 0.0 210.00n 0.0 214.89n 0.0 215.00n 0.5 219.89n 0.5 220.00n 0.5 224.89n 0.5 225.00n 0.5 229.89n 0.5 230.00n 0.0 234.89n 0.0 235.00n 0.5 239.89n 0.5 240.00n 0.5 244.89n 0.5 245.00n 0.0 249.89n 0.0)
Vb24 B[24] 0 PWL(0.00n 0.5 4.89n 0.5 5.00n 0.5 9.89n 0.5 10.00n 0.5 14.89n 0.5 15.00n 0.0 19.89n 0.0 20.00n 0.0 24.89n 0.0 25.00n 0.5 29.89n 0.5 30.00n 0.0 34.89n 0.0 35.00n 0.0 39.89n 0.0 40.00n 0.0 44.89n 0.0 45.00n 0.5 49.89n 0.5 50.00n 0.5 54.89n 0.5 55.00n 0.0 59.89n 0.0 60.00n 0.5 64.89n 0.5 65.00n 0.5 69.89n 0.5 70.00n 0.5 74.89n 0.5 75.00n 0.0 79.89n 0.0 80.00n 0.5 84.89n 0.5 85.00n 0.0 89.89n 0.0 90.00n 0.0 94.89n 0.0 95.00n 0.0 99.89n 0.0 100.00n 0.5 104.89n 0.5 105.00n 0.5 109.89n 0.5 110.00n 0.0 114.89n 0.0 115.00n 0.0 119.89n 0.0 120.00n 0.0 124.89n 0.0 125.00n 0.5 129.89n 0.5 130.00n 0.0 134.89n 0.0 135.00n 0.0 139.89n 0.0 140.00n 0.0 144.89n 0.0 145.00n 0.0 149.89n 0.0 150.00n 0.5 154.89n 0.5 155.00n 0.5 159.89n 0.5 160.00n 0.0 164.89n 0.0 165.00n 0.5 169.89n 0.5 170.00n 0.5 174.89n 0.5 175.00n 0.5 179.89n 0.5 180.00n 0.0 184.89n 0.0 185.00n 0.5 189.89n 0.5 190.00n 0.0 194.89n 0.0 195.00n 0.5 199.89n 0.5 200.00n 0.5 204.89n 0.5 205.00n 0.5 209.89n 0.5 210.00n 0.5 214.89n 0.5 215.00n 0.0 219.89n 0.0 220.00n 0.0 224.89n 0.0 225.00n 0.0 229.89n 0.0 230.00n 0.0 234.89n 0.0 235.00n 0.0 239.89n 0.0 240.00n 0.5 244.89n 0.5 245.00n 0.0 249.89n 0.0)
Va25 A[25] 0 PWL(0.00n 0.0 4.89n 0.0 5.00n 0.5 9.89n 0.5 10.00n 0.5 14.89n 0.5 15.00n 0.5 19.89n 0.5 20.00n 0.0 24.89n 0.0 25.00n 0.0 29.89n 0.0 30.00n 0.5 34.89n 0.5 35.00n 0.0 39.89n 0.0 40.00n 0.0 44.89n 0.0 45.00n 0.0 49.89n 0.0 50.00n 0.5 54.89n 0.5 55.00n 0.5 59.89n 0.5 60.00n 0.0 64.89n 0.0 65.00n 0.5 69.89n 0.5 70.00n 0.5 74.89n 0.5 75.00n 0.5 79.89n 0.5 80.00n 0.0 84.89n 0.0 85.00n 0.5 89.89n 0.5 90.00n 0.0 94.89n 0.0 95.00n 0.0 99.89n 0.0 100.00n 0.0 104.89n 0.0 105.00n 0.5 109.89n 0.5 110.00n 0.5 114.89n 0.5 115.00n 0.0 119.89n 0.0 120.00n 0.0 124.89n 0.0 125.00n 0.0 129.89n 0.0 130.00n 0.5 134.89n 0.5 135.00n 0.0 139.89n 0.0 140.00n 0.0 144.89n 0.0 145.00n 0.0 149.89n 0.0 150.00n 0.0 154.89n 0.0 155.00n 0.5 159.89n 0.5 160.00n 0.5 164.89n 0.5 165.00n 0.0 169.89n 0.0 170.00n 0.5 174.89n 0.5 175.00n 0.5 179.89n 0.5 180.00n 0.5 184.89n 0.5 185.00n 0.0 189.89n 0.0 190.00n 0.5 194.89n 0.5 195.00n 0.0 199.89n 0.0 200.00n 0.5 204.89n 0.5 205.00n 0.5 209.89n 0.5 210.00n 0.5 214.89n 0.5 215.00n 0.5 219.89n 0.5 220.00n 0.0 224.89n 0.0 225.00n 0.0 229.89n 0.0 230.00n 0.0 234.89n 0.0 235.00n 0.0 239.89n 0.0 240.00n 0.0 244.89n 0.0 245.00n 0.5 249.89n 0.5)
Vb25 B[25] 0 PWL(0.00n 0.5 4.89n 0.5 5.00n 0.5 9.89n 0.5 10.00n 0.5 14.89n 0.5 15.00n 0.5 19.89n 0.5 20.00n 0.5 24.89n 0.5 25.00n 0.5 29.89n 0.5 30.00n 0.5 34.89n 0.5 35.00n 0.5 39.89n 0.5 40.00n 0.5 44.89n 0.5 45.00n 0.5 49.89n 0.5 50.00n 0.5 54.89n 0.5 55.00n 0.5 59.89n 0.5 60.00n 0.0 64.89n 0.0 65.00n 0.5 69.89n 0.5 70.00n 0.5 74.89n 0.5 75.00n 0.0 79.89n 0.0 80.00n 0.0 84.89n 0.0 85.00n 0.0 89.89n 0.0 90.00n 0.0 94.89n 0.0 95.00n 0.0 99.89n 0.0 100.00n 0.5 104.89n 0.5 105.00n 0.0 109.89n 0.0 110.00n 0.5 114.89n 0.5 115.00n 0.5 119.89n 0.5 120.00n 0.5 124.89n 0.5 125.00n 0.5 129.89n 0.5 130.00n 0.0 134.89n 0.0 135.00n 0.5 139.89n 0.5 140.00n 0.5 144.89n 0.5 145.00n 0.5 149.89n 0.5 150.00n 0.0 154.89n 0.0 155.00n 0.5 159.89n 0.5 160.00n 0.0 164.89n 0.0 165.00n 0.0 169.89n 0.0 170.00n 0.5 174.89n 0.5 175.00n 0.0 179.89n 0.0 180.00n 0.5 184.89n 0.5 185.00n 0.5 189.89n 0.5 190.00n 0.0 194.89n 0.0 195.00n 0.0 199.89n 0.0 200.00n 0.5 204.89n 0.5 205.00n 0.0 209.89n 0.0 210.00n 0.0 214.89n 0.0 215.00n 0.5 219.89n 0.5 220.00n 0.5 224.89n 0.5 225.00n 0.5 229.89n 0.5 230.00n 0.0 234.89n 0.0 235.00n 0.5 239.89n 0.5 240.00n 0.5 244.89n 0.5 245.00n 0.0 249.89n 0.0)
Va26 A[26] 0 PWL(0.00n 0.5 4.89n 0.5 5.00n 0.5 9.89n 0.5 10.00n 0.5 14.89n 0.5 15.00n 0.5 19.89n 0.5 20.00n 0.5 24.89n 0.5 25.00n 0.5 29.89n 0.5 30.00n 0.5 34.89n 0.5 35.00n 0.5 39.89n 0.5 40.00n 0.5 44.89n 0.5 45.00n 0.5 49.89n 0.5 50.00n 0.5 54.89n 0.5 55.00n 0.5 59.89n 0.5 60.00n 0.5 64.89n 0.5 65.00n 0.0 69.89n 0.0 70.00n 0.5 74.89n 0.5 75.00n 0.5 79.89n 0.5 80.00n 0.0 84.89n 0.0 85.00n 0.0 89.89n 0.0 90.00n 0.0 94.89n 0.0 95.00n 0.0 99.89n 0.0 100.00n 0.0 104.89n 0.0 105.00n 0.5 109.89n 0.5 110.00n 0.0 114.89n 0.0 115.00n 0.5 119.89n 0.5 120.00n 0.5 124.89n 0.5 125.00n 0.5 129.89n 0.5 130.00n 0.5 134.89n 0.5 135.00n 0.0 139.89n 0.0 140.00n 0.5 144.89n 0.5 145.00n 0.5 149.89n 0.5 150.00n 0.5 154.89n 0.5 155.00n 0.0 159.89n 0.0 160.00n 0.5 164.89n 0.5 165.00n 0.0 169.89n 0.0 170.00n 0.0 174.89n 0.0 175.00n 0.5 179.89n 0.5 180.00n 0.0 184.89n 0.0 185.00n 0.5 189.89n 0.5 190.00n 0.5 194.89n 0.5 195.00n 0.0 199.89n 0.0 200.00n 0.0 204.89n 0.0 205.00n 0.5 209.89n 0.5 210.00n 0.0 214.89n 0.0 215.00n 0.0 219.89n 0.0 220.00n 0.5 224.89n 0.5 225.00n 0.5 229.89n 0.5 230.00n 0.5 234.89n 0.5 235.00n 0.0 239.89n 0.0 240.00n 0.5 244.89n 0.5 245.00n 0.5 249.89n 0.5)
Vb26 B[26] 0 PWL(0.00n 0.0 4.89n 0.0 5.00n 0.5 9.89n 0.5 10.00n 0.5 14.89n 0.5 15.00n 0.5 19.89n 0.5 20.00n 0.0 24.89n 0.0 25.00n 0.0 29.89n 0.0 30.00n 0.5 34.89n 0.5 35.00n 0.0 39.89n 0.0 40.00n 0.0 44.89n 0.0 45.00n 0.0 49.89n 0.0 50.00n 0.5 54.89n 0.5 55.00n 0.5 59.89n 0.5 60.00n 0.0 64.89n 0.0 65.00n 0.5 69.89n 0.5 70.00n 0.5 74.89n 0.5 75.00n 0.5 79.89n 0.5 80.00n 0.0 84.89n 0.0 85.00n 0.5 89.89n 0.5 90.00n 0.0 94.89n 0.0 95.00n 0.0 99.89n 0.0 100.00n 0.0 104.89n 0.0 105.00n 0.5 109.89n 0.5 110.00n 0.5 114.89n 0.5 115.00n 0.0 119.89n 0.0 120.00n 0.0 124.89n 0.0 125.00n 0.0 129.89n 0.0 130.00n 0.5 134.89n 0.5 135.00n 0.0 139.89n 0.0 140.00n 0.0 144.89n 0.0 145.00n 0.0 149.89n 0.0 150.00n 0.0 154.89n 0.0 155.00n 0.5 159.89n 0.5 160.00n 0.5 164.89n 0.5 165.00n 0.0 169.89n 0.0 170.00n 0.5 174.89n 0.5 175.00n 0.5 179.89n 0.5 180.00n 0.5 184.89n 0.5 185.00n 0.0 189.89n 0.0 190.00n 0.5 194.89n 0.5 195.00n 0.0 199.89n 0.0 200.00n 0.5 204.89n 0.5 205.00n 0.5 209.89n 0.5 210.00n 0.5 214.89n 0.5 215.00n 0.5 219.89n 0.5 220.00n 0.0 224.89n 0.0 225.00n 0.0 229.89n 0.0 230.00n 0.0 234.89n 0.0 235.00n 0.0 239.89n 0.0 240.00n 0.0 244.89n 0.0 245.00n 0.5 249.89n 0.5)
Va27 A[27] 0 PWL(0.00n 0.0 4.89n 0.0 5.00n 0.0 9.89n 0.0 10.00n 0.5 14.89n 0.5 15.00n 0.5 19.89n 0.5 20.00n 0.5 24.89n 0.5 25.00n 0.0 29.89n 0.0 30.00n 0.0 34.89n 0.0 35.00n 0.5 39.89n 0.5 40.00n 0.0 44.89n 0.0 45.00n 0.0 49.89n 0.0 50.00n 0.0 54.89n 0.0 55.00n 0.5 59.89n 0.5 60.00n 0.5 64.89n 0.5 65.00n 0.0 69.89n 0.0 70.00n 0.5 74.89n 0.5 75.00n 0.5 79.89n 0.5 80.00n 0.5 84.89n 0.5 85.00n 0.0 89.89n 0.0 90.00n 0.5 94.89n 0.5 95.00n 0.0 99.89n 0.0 100.00n 0.0 104.89n 0.0 105.00n 0.0 109.89n 0.0 110.00n 0.5 114.89n 0.5 115.00n 0.5 119.89n 0.5 120.00n 0.0 124.89n 0.0 125.00n 0.0 129.89n 0.0 130.00n 0.0 134.89n 0.0 135.00n 0.5 139.89n 0.5 140.00n 0.0 144.89n 0.0 145.00n 0.0 149.89n 0.0 150.00n 0.0 154.89n 0.0 155.00n 0.0 159.89n 0.0 160.00n 0.5 164.89n 0.5 165.00n 0.5 169.89n 0.5 170.00n 0.0 174.89n 0.0 175.00n 0.5 179.89n 0.5 180.00n 0.5 184.89n 0.5 185.00n 0.5 189.89n 0.5 190.00n 0.0 194.89n 0.0 195.00n 0.5 199.89n 0.5 200.00n 0.0 204.89n 0.0 205.00n 0.5 209.89n 0.5 210.00n 0.5 214.89n 0.5 215.00n 0.5 219.89n 0.5 220.00n 0.5 224.89n 0.5 225.00n 0.0 229.89n 0.0 230.00n 0.0 234.89n 0.0 235.00n 0.0 239.89n 0.0 240.00n 0.0 244.89n 0.0 245.00n 0.0 249.89n 0.0)
Vb27 B[27] 0 PWL(0.00n 0.5 4.89n 0.5 5.00n 0.5 9.89n 0.5 10.00n 0.5 14.89n 0.5 15.00n 0.5 19.89n 0.5 20.00n 0.5 24.89n 0.5 25.00n 0.5 29.89n 0.5 30.00n 0.5 34.89n 0.5 35.00n 0.5 39.89n 0.5 40.00n 0.5 44.89n 0.5 45.00n 0.5 49.89n 0.5 50.00n 0.5 54.89n 0.5 55.00n 0.5 59.89n 0.5 60.00n 0.5 64.89n 0.5 65.00n 0.0 69.89n 0.0 70.00n 0.5 74.89n 0.5 75.00n 0.5 79.89n 0.5 80.00n 0.0 84.89n 0.0 85.00n 0.0 89.89n 0.0 90.00n 0.0 94.89n 0.0 95.00n 0.0 99.89n 0.0 100.00n 0.0 104.89n 0.0 105.00n 0.5 109.89n 0.5 110.00n 0.0 114.89n 0.0 115.00n 0.5 119.89n 0.5 120.00n 0.5 124.89n 0.5 125.00n 0.5 129.89n 0.5 130.00n 0.5 134.89n 0.5 135.00n 0.0 139.89n 0.0 140.00n 0.5 144.89n 0.5 145.00n 0.5 149.89n 0.5 150.00n 0.5 154.89n 0.5 155.00n 0.0 159.89n 0.0 160.00n 0.5 164.89n 0.5 165.00n 0.0 169.89n 0.0 170.00n 0.0 174.89n 0.0 175.00n 0.5 179.89n 0.5 180.00n 0.0 184.89n 0.0 185.00n 0.5 189.89n 0.5 190.00n 0.5 194.89n 0.5 195.00n 0.0 199.89n 0.0 200.00n 0.0 204.89n 0.0 205.00n 0.5 209.89n 0.5 210.00n 0.0 214.89n 0.0 215.00n 0.0 219.89n 0.0 220.00n 0.5 224.89n 0.5 225.00n 0.5 229.89n 0.5 230.00n 0.5 234.89n 0.5 235.00n 0.0 239.89n 0.0 240.00n 0.5 244.89n 0.5 245.00n 0.5 249.89n 0.5)
Va28 A[28] 0 PWL(0.00n 0.5 4.89n 0.5 5.00n 0.5 9.89n 0.5 10.00n 0.5 14.89n 0.5 15.00n 0.5 19.89n 0.5 20.00n 0.5 24.89n 0.5 25.00n 0.5 29.89n 0.5 30.00n 0.5 34.89n 0.5 35.00n 0.5 39.89n 0.5 40.00n 0.5 44.89n 0.5 45.00n 0.5 49.89n 0.5 50.00n 0.5 54.89n 0.5 55.00n 0.5 59.89n 0.5 60.00n 0.5 64.89n 0.5 65.00n 0.5 69.89n 0.5 70.00n 0.0 74.89n 0.0 75.00n 0.5 79.89n 0.5 80.00n 0.5 84.89n 0.5 85.00n 0.0 89.89n 0.0 90.00n 0.0 94.89n 0.0 95.00n 0.0 99.89n 0.0 100.00n 0.0 104.89n 0.0 105.00n 0.0 109.89n 0.0 110.00n 0.5 114.89n 0.5 115.00n 0.0 119.89n 0.0 120.00n 0.5 124.89n 0.5 125.00n 0.5 129.89n 0.5 130.00n 0.5 134.89n 0.5 135.00n 0.5 139.89n 0.5 140.00n 0.0 144.89n 0.0 145.00n 0.5 149.89n 0.5 150.00n 0.5 154.89n 0.5 155.00n 0.5 159.89n 0.5 160.00n 0.0 164.89n 0.0 165.00n 0.5 169.89n 0.5 170.00n 0.0 174.89n 0.0 175.00n 0.0 179.89n 0.0 180.00n 0.5 184.89n 0.5 185.00n 0.0 189.89n 0.0 190.00n 0.5 194.89n 0.5 195.00n 0.5 199.89n 0.5 200.00n 0.0 204.89n 0.0 205.00n 0.0 209.89n 0.0 210.00n 0.5 214.89n 0.5 215.00n 0.0 219.89n 0.0 220.00n 0.0 224.89n 0.0 225.00n 0.5 229.89n 0.5 230.00n 0.5 234.89n 0.5 235.00n 0.5 239.89n 0.5 240.00n 0.0 244.89n 0.0 245.00n 0.5 249.89n 0.5)
Vb28 B[28] 0 PWL(0.00n 0.0 4.89n 0.0 5.00n 0.0 9.89n 0.0 10.00n 0.5 14.89n 0.5 15.00n 0.5 19.89n 0.5 20.00n 0.5 24.89n 0.5 25.00n 0.0 29.89n 0.0 30.00n 0.0 34.89n 0.0 35.00n 0.5 39.89n 0.5 40.00n 0.0 44.89n 0.0 45.00n 0.0 49.89n 0.0 50.00n 0.0 54.89n 0.0 55.00n 0.5 59.89n 0.5 60.00n 0.5 64.89n 0.5 65.00n 0.0 69.89n 0.0 70.00n 0.5 74.89n 0.5 75.00n 0.5 79.89n 0.5 80.00n 0.5 84.89n 0.5 85.00n 0.0 89.89n 0.0 90.00n 0.5 94.89n 0.5 95.00n 0.0 99.89n 0.0 100.00n 0.0 104.89n 0.0 105.00n 0.0 109.89n 0.0 110.00n 0.5 114.89n 0.5 115.00n 0.5 119.89n 0.5 120.00n 0.0 124.89n 0.0 125.00n 0.0 129.89n 0.0 130.00n 0.0 134.89n 0.0 135.00n 0.5 139.89n 0.5 140.00n 0.0 144.89n 0.0 145.00n 0.0 149.89n 0.0 150.00n 0.0 154.89n 0.0 155.00n 0.0 159.89n 0.0 160.00n 0.5 164.89n 0.5 165.00n 0.5 169.89n 0.5 170.00n 0.0 174.89n 0.0 175.00n 0.5 179.89n 0.5 180.00n 0.5 184.89n 0.5 185.00n 0.5 189.89n 0.5 190.00n 0.0 194.89n 0.0 195.00n 0.5 199.89n 0.5 200.00n 0.0 204.89n 0.0 205.00n 0.5 209.89n 0.5 210.00n 0.5 214.89n 0.5 215.00n 0.5 219.89n 0.5 220.00n 0.5 224.89n 0.5 225.00n 0.0 229.89n 0.0 230.00n 0.0 234.89n 0.0 235.00n 0.0 239.89n 0.0 240.00n 0.0 244.89n 0.0 245.00n 0.0 249.89n 0.0)
Va29 A[29] 0 PWL(0.00n 0.0 4.89n 0.0 5.00n 0.0 9.89n 0.0 10.00n 0.0 14.89n 0.0 15.00n 0.5 19.89n 0.5 20.00n 0.5 24.89n 0.5 25.00n 0.5 29.89n 0.5 30.00n 0.0 34.89n 0.0 35.00n 0.0 39.89n 0.0 40.00n 0.5 44.89n 0.5 45.00n 0.0 49.89n 0.0 50.00n 0.0 54.89n 0.0 55.00n 0.0 59.89n 0.0 60.00n 0.5 64.89n 0.5 65.00n 0.5 69.89n 0.5 70.00n 0.0 74.89n 0.0 75.00n 0.5 79.89n 0.5 80.00n 0.5 84.89n 0.5 85.00n 0.5 89.89n 0.5 90.00n 0.0 94.89n 0.0 95.00n 0.5 99.89n 0.5 100.00n 0.0 104.89n 0.0 105.00n 0.0 109.89n 0.0 110.00n 0.0 114.89n 0.0 115.00n 0.5 119.89n 0.5 120.00n 0.5 124.89n 0.5 125.00n 0.0 129.89n 0.0 130.00n 0.0 134.89n 0.0 135.00n 0.0 139.89n 0.0 140.00n 0.5 144.89n 0.5 145.00n 0.0 149.89n 0.0 150.00n 0.0 154.89n 0.0 155.00n 0.0 159.89n 0.0 160.00n 0.0 164.89n 0.0 165.00n 0.5 169.89n 0.5 170.00n 0.5 174.89n 0.5 175.00n 0.0 179.89n 0.0 180.00n 0.5 184.89n 0.5 185.00n 0.5 189.89n 0.5 190.00n 0.5 194.89n 0.5 195.00n 0.0 199.89n 0.0 200.00n 0.5 204.89n 0.5 205.00n 0.0 209.89n 0.0 210.00n 0.5 214.89n 0.5 215.00n 0.5 219.89n 0.5 220.00n 0.5 224.89n 0.5 225.00n 0.5 229.89n 0.5 230.00n 0.0 234.89n 0.0 235.00n 0.0 239.89n 0.0 240.00n 0.0 244.89n 0.0 245.00n 0.0 249.89n 0.0)
Vb29 B[29] 0 PWL(0.00n 0.5 4.89n 0.5 5.00n 0.5 9.89n 0.5 10.00n 0.5 14.89n 0.5 15.00n 0.5 19.89n 0.5 20.00n 0.5 24.89n 0.5 25.00n 0.5 29.89n 0.5 30.00n 0.5 34.89n 0.5 35.00n 0.5 39.89n 0.5 40.00n 0.5 44.89n 0.5 45.00n 0.5 49.89n 0.5 50.00n 0.5 54.89n 0.5 55.00n 0.5 59.89n 0.5 60.00n 0.5 64.89n 0.5 65.00n 0.5 69.89n 0.5 70.00n 0.0 74.89n 0.0 75.00n 0.5 79.89n 0.5 80.00n 0.5 84.89n 0.5 85.00n 0.0 89.89n 0.0 90.00n 0.0 94.89n 0.0 95.00n 0.0 99.89n 0.0 100.00n 0.0 104.89n 0.0 105.00n 0.0 109.89n 0.0 110.00n 0.5 114.89n 0.5 115.00n 0.0 119.89n 0.0 120.00n 0.5 124.89n 0.5 125.00n 0.5 129.89n 0.5 130.00n 0.5 134.89n 0.5 135.00n 0.5 139.89n 0.5 140.00n 0.0 144.89n 0.0 145.00n 0.5 149.89n 0.5 150.00n 0.5 154.89n 0.5 155.00n 0.5 159.89n 0.5 160.00n 0.0 164.89n 0.0 165.00n 0.5 169.89n 0.5 170.00n 0.0 174.89n 0.0 175.00n 0.0 179.89n 0.0 180.00n 0.5 184.89n 0.5 185.00n 0.0 189.89n 0.0 190.00n 0.5 194.89n 0.5 195.00n 0.5 199.89n 0.5 200.00n 0.0 204.89n 0.0 205.00n 0.0 209.89n 0.0 210.00n 0.5 214.89n 0.5 215.00n 0.0 219.89n 0.0 220.00n 0.0 224.89n 0.0 225.00n 0.5 229.89n 0.5 230.00n 0.5 234.89n 0.5 235.00n 0.5 239.89n 0.5 240.00n 0.0 244.89n 0.0 245.00n 0.5 249.89n 0.5)
Va30 A[30] 0 PWL(0.00n 0.0 4.89n 0.0 5.00n 0.5 9.89n 0.5 10.00n 0.5 14.89n 0.5 15.00n 0.5 19.89n 0.5 20.00n 0.5 24.89n 0.5 25.00n 0.5 29.89n 0.5 30.00n 0.5 34.89n 0.5 35.00n 0.5 39.89n 0.5 40.00n 0.5 44.89n 0.5 45.00n 0.5 49.89n 0.5 50.00n 0.5 54.89n 0.5 55.00n 0.5 59.89n 0.5 60.00n 0.5 64.89n 0.5 65.00n 0.5 69.89n 0.5 70.00n 0.5 74.89n 0.5 75.00n 0.0 79.89n 0.0 80.00n 0.5 84.89n 0.5 85.00n 0.5 89.89n 0.5 90.00n 0.0 94.89n 0.0 95.00n 0.0 99.89n 0.0 100.00n 0.0 104.89n 0.0 105.00n 0.0 109.89n 0.0 110.00n 0.0 114.89n 0.0 115.00n 0.5 119.89n 0.5 120.00n 0.0 124.89n 0.0 125.00n 0.5 129.89n 0.5 130.00n 0.5 134.89n 0.5 135.00n 0.5 139.89n 0.5 140.00n 0.5 144.89n 0.5 145.00n 0.0 149.89n 0.0 150.00n 0.5 154.89n 0.5 155.00n 0.5 159.89n 0.5 160.00n 0.5 164.89n 0.5 165.00n 0.0 169.89n 0.0 170.00n 0.5 174.89n 0.5 175.00n 0.0 179.89n 0.0 180.00n 0.0 184.89n 0.0 185.00n 0.5 189.89n 0.5 190.00n 0.0 194.89n 0.0 195.00n 0.5 199.89n 0.5 200.00n 0.5 204.89n 0.5 205.00n 0.0 209.89n 0.0 210.00n 0.0 214.89n 0.0 215.00n 0.5 219.89n 0.5 220.00n 0.0 224.89n 0.0 225.00n 0.0 229.89n 0.0 230.00n 0.5 234.89n 0.5 235.00n 0.5 239.89n 0.5 240.00n 0.5 244.89n 0.5 245.00n 0.0 249.89n 0.0)
Vb30 B[30] 0 PWL(0.00n 0.0 4.89n 0.0 5.00n 0.0 9.89n 0.0 10.00n 0.0 14.89n 0.0 15.00n 0.5 19.89n 0.5 20.00n 0.5 24.89n 0.5 25.00n 0.5 29.89n 0.5 30.00n 0.0 34.89n 0.0 35.00n 0.0 39.89n 0.0 40.00n 0.5 44.89n 0.5 45.00n 0.0 49.89n 0.0 50.00n 0.0 54.89n 0.0 55.00n 0.0 59.89n 0.0 60.00n 0.5 64.89n 0.5 65.00n 0.5 69.89n 0.5 70.00n 0.0 74.89n 0.0 75.00n 0.5 79.89n 0.5 80.00n 0.5 84.89n 0.5 85.00n 0.5 89.89n 0.5 90.00n 0.0 94.89n 0.0 95.00n 0.5 99.89n 0.5 100.00n 0.0 104.89n 0.0 105.00n 0.0 109.89n 0.0 110.00n 0.0 114.89n 0.0 115.00n 0.5 119.89n 0.5 120.00n 0.5 124.89n 0.5 125.00n 0.0 129.89n 0.0 130.00n 0.0 134.89n 0.0 135.00n 0.0 139.89n 0.0 140.00n 0.5 144.89n 0.5 145.00n 0.0 149.89n 0.0 150.00n 0.0 154.89n 0.0 155.00n 0.0 159.89n 0.0 160.00n 0.0 164.89n 0.0 165.00n 0.5 169.89n 0.5 170.00n 0.5 174.89n 0.5 175.00n 0.0 179.89n 0.0 180.00n 0.5 184.89n 0.5 185.00n 0.5 189.89n 0.5 190.00n 0.5 194.89n 0.5 195.00n 0.0 199.89n 0.0 200.00n 0.5 204.89n 0.5 205.00n 0.0 209.89n 0.0 210.00n 0.5 214.89n 0.5 215.00n 0.5 219.89n 0.5 220.00n 0.5 224.89n 0.5 225.00n 0.5 229.89n 0.5 230.00n 0.0 234.89n 0.0 235.00n 0.0 239.89n 0.0 240.00n 0.0 244.89n 0.0 245.00n 0.0 249.89n 0.0)
Va31 A[31] 0 PWL(0.00n 0.5 4.89n 0.5 5.00n 0.0 9.89n 0.0 10.00n 0.0 14.89n 0.0 15.00n 0.0 19.89n 0.0 20.00n 0.5 24.89n 0.5 25.00n 0.5 29.89n 0.5 30.00n 0.5 34.89n 0.5 35.00n 0.0 39.89n 0.0 40.00n 0.0 44.89n 0.0 45.00n 0.5 49.89n 0.5 50.00n 0.0 54.89n 0.0 55.00n 0.0 59.89n 0.0 60.00n 0.0 64.89n 0.0 65.00n 0.5 69.89n 0.5 70.00n 0.5 74.89n 0.5 75.00n 0.0 79.89n 0.0 80.00n 0.5 84.89n 0.5 85.00n 0.5 89.89n 0.5 90.00n 0.5 94.89n 0.5 95.00n 0.0 99.89n 0.0 100.00n 0.5 104.89n 0.5 105.00n 0.0 109.89n 0.0 110.00n 0.0 114.89n 0.0 115.00n 0.0 119.89n 0.0 120.00n 0.5 124.89n 0.5 125.00n 0.5 129.89n 0.5 130.00n 0.0 134.89n 0.0 135.00n 0.0 139.89n 0.0 140.00n 0.0 144.89n 0.0 145.00n 0.5 149.89n 0.5 150.00n 0.0 154.89n 0.0 155.00n 0.0 159.89n 0.0 160.00n 0.0 164.89n 0.0 165.00n 0.0 169.89n 0.0 170.00n 0.5 174.89n 0.5 175.00n 0.5 179.89n 0.5 180.00n 0.0 184.89n 0.0 185.00n 0.5 189.89n 0.5 190.00n 0.5 194.89n 0.5 195.00n 0.5 199.89n 0.5 200.00n 0.0 204.89n 0.0 205.00n 0.5 209.89n 0.5 210.00n 0.0 214.89n 0.0 215.00n 0.5 219.89n 0.5 220.00n 0.5 224.89n 0.5 225.00n 0.5 229.89n 0.5 230.00n 0.5 234.89n 0.5 235.00n 0.0 239.89n 0.0 240.00n 0.0 244.89n 0.0 245.00n 0.0 249.89n 0.0)
Vb31 B[31] 0 PWL(0.00n 0.0 4.89n 0.0 5.00n 0.5 9.89n 0.5 10.00n 0.5 14.89n 0.5 15.00n 0.5 19.89n 0.5 20.00n 0.5 24.89n 0.5 25.00n 0.5 29.89n 0.5 30.00n 0.5 34.89n 0.5 35.00n 0.5 39.89n 0.5 40.00n 0.5 44.89n 0.5 45.00n 0.5 49.89n 0.5 50.00n 0.5 54.89n 0.5 55.00n 0.5 59.89n 0.5 60.00n 0.5 64.89n 0.5 65.00n 0.5 69.89n 0.5 70.00n 0.5 74.89n 0.5 75.00n 0.0 79.89n 0.0 80.00n 0.5 84.89n 0.5 85.00n 0.5 89.89n 0.5 90.00n 0.0 94.89n 0.0 95.00n 0.0 99.89n 0.0 100.00n 0.0 104.89n 0.0 105.00n 0.0 109.89n 0.0 110.00n 0.0 114.89n 0.0 115.00n 0.5 119.89n 0.5 120.00n 0.0 124.89n 0.0 125.00n 0.5 129.89n 0.5 130.00n 0.5 134.89n 0.5 135.00n 0.5 139.89n 0.5 140.00n 0.5 144.89n 0.5 145.00n 0.0 149.89n 0.0 150.00n 0.5 154.89n 0.5 155.00n 0.5 159.89n 0.5 160.00n 0.5 164.89n 0.5 165.00n 0.0 169.89n 0.0 170.00n 0.5 174.89n 0.5 175.00n 0.0 179.89n 0.0 180.00n 0.0 184.89n 0.0 185.00n 0.5 189.89n 0.5 190.00n 0.0 194.89n 0.0 195.00n 0.5 199.89n 0.5 200.00n 0.5 204.89n 0.5 205.00n 0.0 209.89n 0.0 210.00n 0.0 214.89n 0.0 215.00n 0.5 219.89n 0.5 220.00n 0.0 224.89n 0.0 225.00n 0.0 229.89n 0.0 230.00n 0.5 234.89n 0.5 235.00n 0.5 239.89n 0.5 240.00n 0.5 244.89n 0.5 245.00n 0.0 249.89n 0.0)
Va32 A[32] 0 PWL(0.00n 0.5 4.89n 0.5 5.00n 0.0 9.89n 0.0 10.00n 0.5 14.89n 0.5 15.00n 0.5 19.89n 0.5 20.00n 0.5 24.89n 0.5 25.00n 0.5 29.89n 0.5 30.00n 0.5 34.89n 0.5 35.00n 0.5 39.89n 0.5 40.00n 0.5 44.89n 0.5 45.00n 0.5 49.89n 0.5 50.00n 0.5 54.89n 0.5 55.00n 0.5 59.89n 0.5 60.00n 0.5 64.89n 0.5 65.00n 0.5 69.89n 0.5 70.00n 0.5 74.89n 0.5 75.00n 0.5 79.89n 0.5 80.00n 0.0 84.89n 0.0 85.00n 0.5 89.89n 0.5 90.00n 0.5 94.89n 0.5 95.00n 0.0 99.89n 0.0 100.00n 0.0 104.89n 0.0 105.00n 0.0 109.89n 0.0 110.00n 0.0 114.89n 0.0 115.00n 0.0 119.89n 0.0 120.00n 0.5 124.89n 0.5 125.00n 0.0 129.89n 0.0 130.00n 0.5 134.89n 0.5 135.00n 0.5 139.89n 0.5 140.00n 0.5 144.89n 0.5 145.00n 0.5 149.89n 0.5 150.00n 0.0 154.89n 0.0 155.00n 0.5 159.89n 0.5 160.00n 0.5 164.89n 0.5 165.00n 0.5 169.89n 0.5 170.00n 0.0 174.89n 0.0 175.00n 0.5 179.89n 0.5 180.00n 0.0 184.89n 0.0 185.00n 0.0 189.89n 0.0 190.00n 0.5 194.89n 0.5 195.00n 0.0 199.89n 0.0 200.00n 0.5 204.89n 0.5 205.00n 0.5 209.89n 0.5 210.00n 0.0 214.89n 0.0 215.00n 0.0 219.89n 0.0 220.00n 0.5 224.89n 0.5 225.00n 0.0 229.89n 0.0 230.00n 0.0 234.89n 0.0 235.00n 0.5 239.89n 0.5 240.00n 0.5 244.89n 0.5 245.00n 0.5 249.89n 0.5)
Vb32 B[32] 0 PWL(0.00n 0.5 4.89n 0.5 5.00n 0.0 9.89n 0.0 10.00n 0.0 14.89n 0.0 15.00n 0.0 19.89n 0.0 20.00n 0.5 24.89n 0.5 25.00n 0.5 29.89n 0.5 30.00n 0.5 34.89n 0.5 35.00n 0.0 39.89n 0.0 40.00n 0.0 44.89n 0.0 45.00n 0.5 49.89n 0.5 50.00n 0.0 54.89n 0.0 55.00n 0.0 59.89n 0.0 60.00n 0.0 64.89n 0.0 65.00n 0.5 69.89n 0.5 70.00n 0.5 74.89n 0.5 75.00n 0.0 79.89n 0.0 80.00n 0.5 84.89n 0.5 85.00n 0.5 89.89n 0.5 90.00n 0.5 94.89n 0.5 95.00n 0.0 99.89n 0.0 100.00n 0.5 104.89n 0.5 105.00n 0.0 109.89n 0.0 110.00n 0.0 114.89n 0.0 115.00n 0.0 119.89n 0.0 120.00n 0.5 124.89n 0.5 125.00n 0.5 129.89n 0.5 130.00n 0.0 134.89n 0.0 135.00n 0.0 139.89n 0.0 140.00n 0.0 144.89n 0.0 145.00n 0.5 149.89n 0.5 150.00n 0.0 154.89n 0.0 155.00n 0.0 159.89n 0.0 160.00n 0.0 164.89n 0.0 165.00n 0.0 169.89n 0.0 170.00n 0.5 174.89n 0.5 175.00n 0.5 179.89n 0.5 180.00n 0.0 184.89n 0.0 185.00n 0.5 189.89n 0.5 190.00n 0.5 194.89n 0.5 195.00n 0.5 199.89n 0.5 200.00n 0.0 204.89n 0.0 205.00n 0.5 209.89n 0.5 210.00n 0.0 214.89n 0.0 215.00n 0.5 219.89n 0.5 220.00n 0.5 224.89n 0.5 225.00n 0.5 229.89n 0.5 230.00n 0.5 234.89n 0.5 235.00n 0.0 239.89n 0.0 240.00n 0.0 244.89n 0.0 245.00n 0.0 249.89n 0.0)
Va33 A[33] 0 PWL(0.00n 0.5 4.89n 0.5 5.00n 0.5 9.89n 0.5 10.00n 0.0 14.89n 0.0 15.00n 0.0 19.89n 0.0 20.00n 0.0 24.89n 0.0 25.00n 0.5 29.89n 0.5 30.00n 0.5 34.89n 0.5 35.00n 0.5 39.89n 0.5 40.00n 0.0 44.89n 0.0 45.00n 0.0 49.89n 0.0 50.00n 0.5 54.89n 0.5 55.00n 0.0 59.89n 0.0 60.00n 0.0 64.89n 0.0 65.00n 0.0 69.89n 0.0 70.00n 0.5 74.89n 0.5 75.00n 0.5 79.89n 0.5 80.00n 0.0 84.89n 0.0 85.00n 0.5 89.89n 0.5 90.00n 0.5 94.89n 0.5 95.00n 0.5 99.89n 0.5 100.00n 0.0 104.89n 0.0 105.00n 0.5 109.89n 0.5 110.00n 0.0 114.89n 0.0 115.00n 0.0 119.89n 0.0 120.00n 0.0 124.89n 0.0 125.00n 0.5 129.89n 0.5 130.00n 0.5 134.89n 0.5 135.00n 0.0 139.89n 0.0 140.00n 0.0 144.89n 0.0 145.00n 0.0 149.89n 0.0 150.00n 0.5 154.89n 0.5 155.00n 0.0 159.89n 0.0 160.00n 0.0 164.89n 0.0 165.00n 0.0 169.89n 0.0 170.00n 0.0 174.89n 0.0 175.00n 0.5 179.89n 0.5 180.00n 0.5 184.89n 0.5 185.00n 0.0 189.89n 0.0 190.00n 0.5 194.89n 0.5 195.00n 0.5 199.89n 0.5 200.00n 0.5 204.89n 0.5 205.00n 0.0 209.89n 0.0 210.00n 0.5 214.89n 0.5 215.00n 0.0 219.89n 0.0 220.00n 0.5 224.89n 0.5 225.00n 0.5 229.89n 0.5 230.00n 0.5 234.89n 0.5 235.00n 0.5 239.89n 0.5 240.00n 0.0 244.89n 0.0 245.00n 0.0 249.89n 0.0)
Vb33 B[33] 0 PWL(0.00n 0.5 4.89n 0.5 5.00n 0.0 9.89n 0.0 10.00n 0.5 14.89n 0.5 15.00n 0.5 19.89n 0.5 20.00n 0.5 24.89n 0.5 25.00n 0.5 29.89n 0.5 30.00n 0.5 34.89n 0.5 35.00n 0.5 39.89n 0.5 40.00n 0.5 44.89n 0.5 45.00n 0.5 49.89n 0.5 50.00n 0.5 54.89n 0.5 55.00n 0.5 59.89n 0.5 60.00n 0.5 64.89n 0.5 65.00n 0.5 69.89n 0.5 70.00n 0.5 74.89n 0.5 75.00n 0.5 79.89n 0.5 80.00n 0.0 84.89n 0.0 85.00n 0.5 89.89n 0.5 90.00n 0.5 94.89n 0.5 95.00n 0.0 99.89n 0.0 100.00n 0.0 104.89n 0.0 105.00n 0.0 109.89n 0.0 110.00n 0.0 114.89n 0.0 115.00n 0.0 119.89n 0.0 120.00n 0.5 124.89n 0.5 125.00n 0.0 129.89n 0.0 130.00n 0.5 134.89n 0.5 135.00n 0.5 139.89n 0.5 140.00n 0.5 144.89n 0.5 145.00n 0.5 149.89n 0.5 150.00n 0.0 154.89n 0.0 155.00n 0.5 159.89n 0.5 160.00n 0.5 164.89n 0.5 165.00n 0.5 169.89n 0.5 170.00n 0.0 174.89n 0.0 175.00n 0.5 179.89n 0.5 180.00n 0.0 184.89n 0.0 185.00n 0.0 189.89n 0.0 190.00n 0.5 194.89n 0.5 195.00n 0.0 199.89n 0.0 200.00n 0.5 204.89n 0.5 205.00n 0.5 209.89n 0.5 210.00n 0.0 214.89n 0.0 215.00n 0.0 219.89n 0.0 220.00n 0.5 224.89n 0.5 225.00n 0.0 229.89n 0.0 230.00n 0.0 234.89n 0.0 235.00n 0.5 239.89n 0.5 240.00n 0.5 244.89n 0.5 245.00n 0.5 249.89n 0.5)
Va34 A[34] 0 PWL(0.00n 0.5 4.89n 0.5 5.00n 0.5 9.89n 0.5 10.00n 0.0 14.89n 0.0 15.00n 0.5 19.89n 0.5 20.00n 0.5 24.89n 0.5 25.00n 0.5 29.89n 0.5 30.00n 0.5 34.89n 0.5 35.00n 0.5 39.89n 0.5 40.00n 0.5 44.89n 0.5 45.00n 0.5 49.89n 0.5 50.00n 0.5 54.89n 0.5 55.00n 0.5 59.89n 0.5 60.00n 0.5 64.89n 0.5 65.00n 0.5 69.89n 0.5 70.00n 0.5 74.89n 0.5 75.00n 0.5 79.89n 0.5 80.00n 0.5 84.89n 0.5 85.00n 0.0 89.89n 0.0 90.00n 0.5 94.89n 0.5 95.00n 0.5 99.89n 0.5 100.00n 0.0 104.89n 0.0 105.00n 0.0 109.89n 0.0 110.00n 0.0 114.89n 0.0 115.00n 0.0 119.89n 0.0 120.00n 0.0 124.89n 0.0 125.00n 0.5 129.89n 0.5 130.00n 0.0 134.89n 0.0 135.00n 0.5 139.89n 0.5 140.00n 0.5 144.89n 0.5 145.00n 0.5 149.89n 0.5 150.00n 0.5 154.89n 0.5 155.00n 0.0 159.89n 0.0 160.00n 0.5 164.89n 0.5 165.00n 0.5 169.89n 0.5 170.00n 0.5 174.89n 0.5 175.00n 0.0 179.89n 0.0 180.00n 0.5 184.89n 0.5 185.00n 0.0 189.89n 0.0 190.00n 0.0 194.89n 0.0 195.00n 0.5 199.89n 0.5 200.00n 0.0 204.89n 0.0 205.00n 0.5 209.89n 0.5 210.00n 0.5 214.89n 0.5 215.00n 0.0 219.89n 0.0 220.00n 0.0 224.89n 0.0 225.00n 0.5 229.89n 0.5 230.00n 0.0 234.89n 0.0 235.00n 0.0 239.89n 0.0 240.00n 0.5 244.89n 0.5 245.00n 0.5 249.89n 0.5)
Vb34 B[34] 0 PWL(0.00n 0.5 4.89n 0.5 5.00n 0.5 9.89n 0.5 10.00n 0.0 14.89n 0.0 15.00n 0.0 19.89n 0.0 20.00n 0.0 24.89n 0.0 25.00n 0.5 29.89n 0.5 30.00n 0.5 34.89n 0.5 35.00n 0.5 39.89n 0.5 40.00n 0.0 44.89n 0.0 45.00n 0.0 49.89n 0.0 50.00n 0.5 54.89n 0.5 55.00n 0.0 59.89n 0.0 60.00n 0.0 64.89n 0.0 65.00n 0.0 69.89n 0.0 70.00n 0.5 74.89n 0.5 75.00n 0.5 79.89n 0.5 80.00n 0.0 84.89n 0.0 85.00n 0.5 89.89n 0.5 90.00n 0.5 94.89n 0.5 95.00n 0.5 99.89n 0.5 100.00n 0.0 104.89n 0.0 105.00n 0.5 109.89n 0.5 110.00n 0.0 114.89n 0.0 115.00n 0.0 119.89n 0.0 120.00n 0.0 124.89n 0.0 125.00n 0.5 129.89n 0.5 130.00n 0.5 134.89n 0.5 135.00n 0.0 139.89n 0.0 140.00n 0.0 144.89n 0.0 145.00n 0.0 149.89n 0.0 150.00n 0.5 154.89n 0.5 155.00n 0.0 159.89n 0.0 160.00n 0.0 164.89n 0.0 165.00n 0.0 169.89n 0.0 170.00n 0.0 174.89n 0.0 175.00n 0.5 179.89n 0.5 180.00n 0.5 184.89n 0.5 185.00n 0.0 189.89n 0.0 190.00n 0.5 194.89n 0.5 195.00n 0.5 199.89n 0.5 200.00n 0.5 204.89n 0.5 205.00n 0.0 209.89n 0.0 210.00n 0.5 214.89n 0.5 215.00n 0.0 219.89n 0.0 220.00n 0.5 224.89n 0.5 225.00n 0.5 229.89n 0.5 230.00n 0.5 234.89n 0.5 235.00n 0.5 239.89n 0.5 240.00n 0.0 244.89n 0.0 245.00n 0.0 249.89n 0.0)
Va35 A[35] 0 PWL(0.00n 0.5 4.89n 0.5 5.00n 0.5 9.89n 0.5 10.00n 0.5 14.89n 0.5 15.00n 0.0 19.89n 0.0 20.00n 0.0 24.89n 0.0 25.00n 0.0 29.89n 0.0 30.00n 0.5 34.89n 0.5 35.00n 0.5 39.89n 0.5 40.00n 0.5 44.89n 0.5 45.00n 0.0 49.89n 0.0 50.00n 0.0 54.89n 0.0 55.00n 0.5 59.89n 0.5 60.00n 0.0 64.89n 0.0 65.00n 0.0 69.89n 0.0 70.00n 0.0 74.89n 0.0 75.00n 0.5 79.89n 0.5 80.00n 0.5 84.89n 0.5 85.00n 0.0 89.89n 0.0 90.00n 0.5 94.89n 0.5 95.00n 0.5 99.89n 0.5 100.00n 0.5 104.89n 0.5 105.00n 0.0 109.89n 0.0 110.00n 0.5 114.89n 0.5 115.00n 0.0 119.89n 0.0 120.00n 0.0 124.89n 0.0 125.00n 0.0 129.89n 0.0 130.00n 0.5 134.89n 0.5 135.00n 0.5 139.89n 0.5 140.00n 0.0 144.89n 0.0 145.00n 0.0 149.89n 0.0 150.00n 0.0 154.89n 0.0 155.00n 0.5 159.89n 0.5 160.00n 0.0 164.89n 0.0 165.00n 0.0 169.89n 0.0 170.00n 0.0 174.89n 0.0 175.00n 0.0 179.89n 0.0 180.00n 0.5 184.89n 0.5 185.00n 0.5 189.89n 0.5 190.00n 0.0 194.89n 0.0 195.00n 0.5 199.89n 0.5 200.00n 0.5 204.89n 0.5 205.00n 0.5 209.89n 0.5 210.00n 0.0 214.89n 0.0 215.00n 0.5 219.89n 0.5 220.00n 0.0 224.89n 0.0 225.00n 0.5 229.89n 0.5 230.00n 0.5 234.89n 0.5 235.00n 0.5 239.89n 0.5 240.00n 0.5 244.89n 0.5 245.00n 0.0 249.89n 0.0)
Vb35 B[35] 0 PWL(0.00n 0.5 4.89n 0.5 5.00n 0.5 9.89n 0.5 10.00n 0.0 14.89n 0.0 15.00n 0.5 19.89n 0.5 20.00n 0.5 24.89n 0.5 25.00n 0.5 29.89n 0.5 30.00n 0.5 34.89n 0.5 35.00n 0.5 39.89n 0.5 40.00n 0.5 44.89n 0.5 45.00n 0.5 49.89n 0.5 50.00n 0.5 54.89n 0.5 55.00n 0.5 59.89n 0.5 60.00n 0.5 64.89n 0.5 65.00n 0.5 69.89n 0.5 70.00n 0.5 74.89n 0.5 75.00n 0.5 79.89n 0.5 80.00n 0.5 84.89n 0.5 85.00n 0.0 89.89n 0.0 90.00n 0.5 94.89n 0.5 95.00n 0.5 99.89n 0.5 100.00n 0.0 104.89n 0.0 105.00n 0.0 109.89n 0.0 110.00n 0.0 114.89n 0.0 115.00n 0.0 119.89n 0.0 120.00n 0.0 124.89n 0.0 125.00n 0.5 129.89n 0.5 130.00n 0.0 134.89n 0.0 135.00n 0.5 139.89n 0.5 140.00n 0.5 144.89n 0.5 145.00n 0.5 149.89n 0.5 150.00n 0.5 154.89n 0.5 155.00n 0.0 159.89n 0.0 160.00n 0.5 164.89n 0.5 165.00n 0.5 169.89n 0.5 170.00n 0.5 174.89n 0.5 175.00n 0.0 179.89n 0.0 180.00n 0.5 184.89n 0.5 185.00n 0.0 189.89n 0.0 190.00n 0.0 194.89n 0.0 195.00n 0.5 199.89n 0.5 200.00n 0.0 204.89n 0.0 205.00n 0.5 209.89n 0.5 210.00n 0.5 214.89n 0.5 215.00n 0.0 219.89n 0.0 220.00n 0.0 224.89n 0.0 225.00n 0.5 229.89n 0.5 230.00n 0.0 234.89n 0.0 235.00n 0.0 239.89n 0.0 240.00n 0.5 244.89n 0.5 245.00n 0.5 249.89n 0.5)
Va36 A[36] 0 PWL(0.00n 0.5 4.89n 0.5 5.00n 0.5 9.89n 0.5 10.00n 0.5 14.89n 0.5 15.00n 0.0 19.89n 0.0 20.00n 0.5 24.89n 0.5 25.00n 0.5 29.89n 0.5 30.00n 0.5 34.89n 0.5 35.00n 0.5 39.89n 0.5 40.00n 0.5 44.89n 0.5 45.00n 0.5 49.89n 0.5 50.00n 0.5 54.89n 0.5 55.00n 0.5 59.89n 0.5 60.00n 0.5 64.89n 0.5 65.00n 0.5 69.89n 0.5 70.00n 0.5 74.89n 0.5 75.00n 0.5 79.89n 0.5 80.00n 0.5 84.89n 0.5 85.00n 0.5 89.89n 0.5 90.00n 0.0 94.89n 0.0 95.00n 0.5 99.89n 0.5 100.00n 0.5 104.89n 0.5 105.00n 0.0 109.89n 0.0 110.00n 0.0 114.89n 0.0 115.00n 0.0 119.89n 0.0 120.00n 0.0 124.89n 0.0 125.00n 0.0 129.89n 0.0 130.00n 0.5 134.89n 0.5 135.00n 0.0 139.89n 0.0 140.00n 0.5 144.89n 0.5 145.00n 0.5 149.89n 0.5 150.00n 0.5 154.89n 0.5 155.00n 0.5 159.89n 0.5 160.00n 0.0 164.89n 0.0 165.00n 0.5 169.89n 0.5 170.00n 0.5 174.89n 0.5 175.00n 0.5 179.89n 0.5 180.00n 0.0 184.89n 0.0 185.00n 0.5 189.89n 0.5 190.00n 0.0 194.89n 0.0 195.00n 0.0 199.89n 0.0 200.00n 0.5 204.89n 0.5 205.00n 0.0 209.89n 0.0 210.00n 0.5 214.89n 0.5 215.00n 0.5 219.89n 0.5 220.00n 0.0 224.89n 0.0 225.00n 0.0 229.89n 0.0 230.00n 0.5 234.89n 0.5 235.00n 0.0 239.89n 0.0 240.00n 0.0 244.89n 0.0 245.00n 0.5 249.89n 0.5)
Vb36 B[36] 0 PWL(0.00n 0.5 4.89n 0.5 5.00n 0.5 9.89n 0.5 10.00n 0.5 14.89n 0.5 15.00n 0.0 19.89n 0.0 20.00n 0.0 24.89n 0.0 25.00n 0.0 29.89n 0.0 30.00n 0.5 34.89n 0.5 35.00n 0.5 39.89n 0.5 40.00n 0.5 44.89n 0.5 45.00n 0.0 49.89n 0.0 50.00n 0.0 54.89n 0.0 55.00n 0.5 59.89n 0.5 60.00n 0.0 64.89n 0.0 65.00n 0.0 69.89n 0.0 70.00n 0.0 74.89n 0.0 75.00n 0.5 79.89n 0.5 80.00n 0.5 84.89n 0.5 85.00n 0.0 89.89n 0.0 90.00n 0.5 94.89n 0.5 95.00n 0.5 99.89n 0.5 100.00n 0.5 104.89n 0.5 105.00n 0.0 109.89n 0.0 110.00n 0.5 114.89n 0.5 115.00n 0.0 119.89n 0.0 120.00n 0.0 124.89n 0.0 125.00n 0.0 129.89n 0.0 130.00n 0.5 134.89n 0.5 135.00n 0.5 139.89n 0.5 140.00n 0.0 144.89n 0.0 145.00n 0.0 149.89n 0.0 150.00n 0.0 154.89n 0.0 155.00n 0.5 159.89n 0.5 160.00n 0.0 164.89n 0.0 165.00n 0.0 169.89n 0.0 170.00n 0.0 174.89n 0.0 175.00n 0.0 179.89n 0.0 180.00n 0.5 184.89n 0.5 185.00n 0.5 189.89n 0.5 190.00n 0.0 194.89n 0.0 195.00n 0.5 199.89n 0.5 200.00n 0.5 204.89n 0.5 205.00n 0.5 209.89n 0.5 210.00n 0.0 214.89n 0.0 215.00n 0.5 219.89n 0.5 220.00n 0.0 224.89n 0.0 225.00n 0.5 229.89n 0.5 230.00n 0.5 234.89n 0.5 235.00n 0.5 239.89n 0.5 240.00n 0.5 244.89n 0.5 245.00n 0.0 249.89n 0.0)
Va37 A[37] 0 PWL(0.00n 0.0 4.89n 0.0 5.00n 0.5 9.89n 0.5 10.00n 0.5 14.89n 0.5 15.00n 0.5 19.89n 0.5 20.00n 0.0 24.89n 0.0 25.00n 0.0 29.89n 0.0 30.00n 0.0 34.89n 0.0 35.00n 0.5 39.89n 0.5 40.00n 0.5 44.89n 0.5 45.00n 0.5 49.89n 0.5 50.00n 0.0 54.89n 0.0 55.00n 0.0 59.89n 0.0 60.00n 0.5 64.89n 0.5 65.00n 0.0 69.89n 0.0 70.00n 0.0 74.89n 0.0 75.00n 0.0 79.89n 0.0 80.00n 0.5 84.89n 0.5 85.00n 0.5 89.89n 0.5 90.00n 0.0 94.89n 0.0 95.00n 0.5 99.89n 0.5 100.00n 0.5 104.89n 0.5 105.00n 0.5 109.89n 0.5 110.00n 0.0 114.89n 0.0 115.00n 0.5 119.89n 0.5 120.00n 0.0 124.89n 0.0 125.00n 0.0 129.89n 0.0 130.00n 0.0 134.89n 0.0 135.00n 0.5 139.89n 0.5 140.00n 0.5 144.89n 0.5 145.00n 0.0 149.89n 0.0 150.00n 0.0 154.89n 0.0 155.00n 0.0 159.89n 0.0 160.00n 0.5 164.89n 0.5 165.00n 0.0 169.89n 0.0 170.00n 0.0 174.89n 0.0 175.00n 0.0 179.89n 0.0 180.00n 0.0 184.89n 0.0 185.00n 0.5 189.89n 0.5 190.00n 0.5 194.89n 0.5 195.00n 0.0 199.89n 0.0 200.00n 0.5 204.89n 0.5 205.00n 0.5 209.89n 0.5 210.00n 0.5 214.89n 0.5 215.00n 0.0 219.89n 0.0 220.00n 0.5 224.89n 0.5 225.00n 0.0 229.89n 0.0 230.00n 0.5 234.89n 0.5 235.00n 0.5 239.89n 0.5 240.00n 0.5 244.89n 0.5 245.00n 0.5 249.89n 0.5)
Vb37 B[37] 0 PWL(0.00n 0.5 4.89n 0.5 5.00n 0.5 9.89n 0.5 10.00n 0.5 14.89n 0.5 15.00n 0.0 19.89n 0.0 20.00n 0.5 24.89n 0.5 25.00n 0.5 29.89n 0.5 30.00n 0.5 34.89n 0.5 35.00n 0.5 39.89n 0.5 40.00n 0.5 44.89n 0.5 45.00n 0.5 49.89n 0.5 50.00n 0.5 54.89n 0.5 55.00n 0.5 59.89n 0.5 60.00n 0.5 64.89n 0.5 65.00n 0.5 69.89n 0.5 70.00n 0.5 74.89n 0.5 75.00n 0.5 79.89n 0.5 80.00n 0.5 84.89n 0.5 85.00n 0.5 89.89n 0.5 90.00n 0.0 94.89n 0.0 95.00n 0.5 99.89n 0.5 100.00n 0.5 104.89n 0.5 105.00n 0.0 109.89n 0.0 110.00n 0.0 114.89n 0.0 115.00n 0.0 119.89n 0.0 120.00n 0.0 124.89n 0.0 125.00n 0.0 129.89n 0.0 130.00n 0.5 134.89n 0.5 135.00n 0.0 139.89n 0.0 140.00n 0.5 144.89n 0.5 145.00n 0.5 149.89n 0.5 150.00n 0.5 154.89n 0.5 155.00n 0.5 159.89n 0.5 160.00n 0.0 164.89n 0.0 165.00n 0.5 169.89n 0.5 170.00n 0.5 174.89n 0.5 175.00n 0.5 179.89n 0.5 180.00n 0.0 184.89n 0.0 185.00n 0.5 189.89n 0.5 190.00n 0.0 194.89n 0.0 195.00n 0.0 199.89n 0.0 200.00n 0.5 204.89n 0.5 205.00n 0.0 209.89n 0.0 210.00n 0.5 214.89n 0.5 215.00n 0.5 219.89n 0.5 220.00n 0.0 224.89n 0.0 225.00n 0.0 229.89n 0.0 230.00n 0.5 234.89n 0.5 235.00n 0.0 239.89n 0.0 240.00n 0.0 244.89n 0.0 245.00n 0.5 249.89n 0.5)
Va38 A[38] 0 PWL(0.00n 0.5 4.89n 0.5 5.00n 0.5 9.89n 0.5 10.00n 0.5 14.89n 0.5 15.00n 0.5 19.89n 0.5 20.00n 0.0 24.89n 0.0 25.00n 0.5 29.89n 0.5 30.00n 0.5 34.89n 0.5 35.00n 0.5 39.89n 0.5 40.00n 0.5 44.89n 0.5 45.00n 0.5 49.89n 0.5 50.00n 0.5 54.89n 0.5 55.00n 0.5 59.89n 0.5 60.00n 0.5 64.89n 0.5 65.00n 0.5 69.89n 0.5 70.00n 0.5 74.89n 0.5 75.00n 0.5 79.89n 0.5 80.00n 0.5 84.89n 0.5 85.00n 0.5 89.89n 0.5 90.00n 0.5 94.89n 0.5 95.00n 0.0 99.89n 0.0 100.00n 0.5 104.89n 0.5 105.00n 0.5 109.89n 0.5 110.00n 0.0 114.89n 0.0 115.00n 0.0 119.89n 0.0 120.00n 0.0 124.89n 0.0 125.00n 0.0 129.89n 0.0 130.00n 0.0 134.89n 0.0 135.00n 0.5 139.89n 0.5 140.00n 0.0 144.89n 0.0 145.00n 0.5 149.89n 0.5 150.00n 0.5 154.89n 0.5 155.00n 0.5 159.89n 0.5 160.00n 0.5 164.89n 0.5 165.00n 0.0 169.89n 0.0 170.00n 0.5 174.89n 0.5 175.00n 0.5 179.89n 0.5 180.00n 0.5 184.89n 0.5 185.00n 0.0 189.89n 0.0 190.00n 0.5 194.89n 0.5 195.00n 0.0 199.89n 0.0 200.00n 0.0 204.89n 0.0 205.00n 0.5 209.89n 0.5 210.00n 0.0 214.89n 0.0 215.00n 0.5 219.89n 0.5 220.00n 0.5 224.89n 0.5 225.00n 0.0 229.89n 0.0 230.00n 0.0 234.89n 0.0 235.00n 0.5 239.89n 0.5 240.00n 0.0 244.89n 0.0 245.00n 0.0 249.89n 0.0)
Vb38 B[38] 0 PWL(0.00n 0.0 4.89n 0.0 5.00n 0.5 9.89n 0.5 10.00n 0.5 14.89n 0.5 15.00n 0.5 19.89n 0.5 20.00n 0.0 24.89n 0.0 25.00n 0.0 29.89n 0.0 30.00n 0.0 34.89n 0.0 35.00n 0.5 39.89n 0.5 40.00n 0.5 44.89n 0.5 45.00n 0.5 49.89n 0.5 50.00n 0.0 54.89n 0.0 55.00n 0.0 59.89n 0.0 60.00n 0.5 64.89n 0.5 65.00n 0.0 69.89n 0.0 70.00n 0.0 74.89n 0.0 75.00n 0.0 79.89n 0.0 80.00n 0.5 84.89n 0.5 85.00n 0.5 89.89n 0.5 90.00n 0.0 94.89n 0.0 95.00n 0.5 99.89n 0.5 100.00n 0.5 104.89n 0.5 105.00n 0.5 109.89n 0.5 110.00n 0.0 114.89n 0.0 115.00n 0.5 119.89n 0.5 120.00n 0.0 124.89n 0.0 125.00n 0.0 129.89n 0.0 130.00n 0.0 134.89n 0.0 135.00n 0.5 139.89n 0.5 140.00n 0.5 144.89n 0.5 145.00n 0.0 149.89n 0.0 150.00n 0.0 154.89n 0.0 155.00n 0.0 159.89n 0.0 160.00n 0.5 164.89n 0.5 165.00n 0.0 169.89n 0.0 170.00n 0.0 174.89n 0.0 175.00n 0.0 179.89n 0.0 180.00n 0.0 184.89n 0.0 185.00n 0.5 189.89n 0.5 190.00n 0.5 194.89n 0.5 195.00n 0.0 199.89n 0.0 200.00n 0.5 204.89n 0.5 205.00n 0.5 209.89n 0.5 210.00n 0.5 214.89n 0.5 215.00n 0.0 219.89n 0.0 220.00n 0.5 224.89n 0.5 225.00n 0.0 229.89n 0.0 230.00n 0.5 234.89n 0.5 235.00n 0.5 239.89n 0.5 240.00n 0.5 244.89n 0.5 245.00n 0.5 249.89n 0.5)
Va39 A[39] 0 PWL(0.00n 0.5 4.89n 0.5 5.00n 0.0 9.89n 0.0 10.00n 0.5 14.89n 0.5 15.00n 0.5 19.89n 0.5 20.00n 0.5 24.89n 0.5 25.00n 0.0 29.89n 0.0 30.00n 0.0 34.89n 0.0 35.00n 0.0 39.89n 0.0 40.00n 0.5 44.89n 0.5 45.00n 0.5 49.89n 0.5 50.00n 0.5 54.89n 0.5 55.00n 0.0 59.89n 0.0 60.00n 0.0 64.89n 0.0 65.00n 0.5 69.89n 0.5 70.00n 0.0 74.89n 0.0 75.00n 0.0 79.89n 0.0 80.00n 0.0 84.89n 0.0 85.00n 0.5 89.89n 0.5 90.00n 0.5 94.89n 0.5 95.00n 0.0 99.89n 0.0 100.00n 0.5 104.89n 0.5 105.00n 0.5 109.89n 0.5 110.00n 0.5 114.89n 0.5 115.00n 0.0 119.89n 0.0 120.00n 0.5 124.89n 0.5 125.00n 0.0 129.89n 0.0 130.00n 0.0 134.89n 0.0 135.00n 0.0 139.89n 0.0 140.00n 0.5 144.89n 0.5 145.00n 0.5 149.89n 0.5 150.00n 0.0 154.89n 0.0 155.00n 0.0 159.89n 0.0 160.00n 0.0 164.89n 0.0 165.00n 0.5 169.89n 0.5 170.00n 0.0 174.89n 0.0 175.00n 0.0 179.89n 0.0 180.00n 0.0 184.89n 0.0 185.00n 0.0 189.89n 0.0 190.00n 0.5 194.89n 0.5 195.00n 0.5 199.89n 0.5 200.00n 0.0 204.89n 0.0 205.00n 0.5 209.89n 0.5 210.00n 0.5 214.89n 0.5 215.00n 0.5 219.89n 0.5 220.00n 0.0 224.89n 0.0 225.00n 0.5 229.89n 0.5 230.00n 0.0 234.89n 0.0 235.00n 0.5 239.89n 0.5 240.00n 0.5 244.89n 0.5 245.00n 0.5 249.89n 0.5)
Vb39 B[39] 0 PWL(0.00n 0.5 4.89n 0.5 5.00n 0.5 9.89n 0.5 10.00n 0.5 14.89n 0.5 15.00n 0.5 19.89n 0.5 20.00n 0.0 24.89n 0.0 25.00n 0.5 29.89n 0.5 30.00n 0.5 34.89n 0.5 35.00n 0.5 39.89n 0.5 40.00n 0.5 44.89n 0.5 45.00n 0.5 49.89n 0.5 50.00n 0.5 54.89n 0.5 55.00n 0.5 59.89n 0.5 60.00n 0.5 64.89n 0.5 65.00n 0.5 69.89n 0.5 70.00n 0.5 74.89n 0.5 75.00n 0.5 79.89n 0.5 80.00n 0.5 84.89n 0.5 85.00n 0.5 89.89n 0.5 90.00n 0.5 94.89n 0.5 95.00n 0.0 99.89n 0.0 100.00n 0.5 104.89n 0.5 105.00n 0.5 109.89n 0.5 110.00n 0.0 114.89n 0.0 115.00n 0.0 119.89n 0.0 120.00n 0.0 124.89n 0.0 125.00n 0.0 129.89n 0.0 130.00n 0.0 134.89n 0.0 135.00n 0.5 139.89n 0.5 140.00n 0.0 144.89n 0.0 145.00n 0.5 149.89n 0.5 150.00n 0.5 154.89n 0.5 155.00n 0.5 159.89n 0.5 160.00n 0.5 164.89n 0.5 165.00n 0.0 169.89n 0.0 170.00n 0.5 174.89n 0.5 175.00n 0.5 179.89n 0.5 180.00n 0.5 184.89n 0.5 185.00n 0.0 189.89n 0.0 190.00n 0.5 194.89n 0.5 195.00n 0.0 199.89n 0.0 200.00n 0.0 204.89n 0.0 205.00n 0.5 209.89n 0.5 210.00n 0.0 214.89n 0.0 215.00n 0.5 219.89n 0.5 220.00n 0.5 224.89n 0.5 225.00n 0.0 229.89n 0.0 230.00n 0.0 234.89n 0.0 235.00n 0.5 239.89n 0.5 240.00n 0.0 244.89n 0.0 245.00n 0.0 249.89n 0.0)
Va40 A[40] 0 PWL(0.00n 0.5 4.89n 0.5 5.00n 0.5 9.89n 0.5 10.00n 0.5 14.89n 0.5 15.00n 0.5 19.89n 0.5 20.00n 0.5 24.89n 0.5 25.00n 0.0 29.89n 0.0 30.00n 0.5 34.89n 0.5 35.00n 0.5 39.89n 0.5 40.00n 0.5 44.89n 0.5 45.00n 0.5 49.89n 0.5 50.00n 0.5 54.89n 0.5 55.00n 0.5 59.89n 0.5 60.00n 0.5 64.89n 0.5 65.00n 0.5 69.89n 0.5 70.00n 0.5 74.89n 0.5 75.00n 0.5 79.89n 0.5 80.00n 0.5 84.89n 0.5 85.00n 0.5 89.89n 0.5 90.00n 0.5 94.89n 0.5 95.00n 0.5 99.89n 0.5 100.00n 0.0 104.89n 0.0 105.00n 0.5 109.89n 0.5 110.00n 0.5 114.89n 0.5 115.00n 0.0 119.89n 0.0 120.00n 0.0 124.89n 0.0 125.00n 0.0 129.89n 0.0 130.00n 0.0 134.89n 0.0 135.00n 0.0 139.89n 0.0 140.00n 0.5 144.89n 0.5 145.00n 0.0 149.89n 0.0 150.00n 0.5 154.89n 0.5 155.00n 0.5 159.89n 0.5 160.00n 0.5 164.89n 0.5 165.00n 0.5 169.89n 0.5 170.00n 0.0 174.89n 0.0 175.00n 0.5 179.89n 0.5 180.00n 0.5 184.89n 0.5 185.00n 0.5 189.89n 0.5 190.00n 0.0 194.89n 0.0 195.00n 0.5 199.89n 0.5 200.00n 0.0 204.89n 0.0 205.00n 0.0 209.89n 0.0 210.00n 0.5 214.89n 0.5 215.00n 0.0 219.89n 0.0 220.00n 0.5 224.89n 0.5 225.00n 0.5 229.89n 0.5 230.00n 0.0 234.89n 0.0 235.00n 0.0 239.89n 0.0 240.00n 0.5 244.89n 0.5 245.00n 0.0 249.89n 0.0)
Vb40 B[40] 0 PWL(0.00n 0.5 4.89n 0.5 5.00n 0.0 9.89n 0.0 10.00n 0.5 14.89n 0.5 15.00n 0.5 19.89n 0.5 20.00n 0.5 24.89n 0.5 25.00n 0.0 29.89n 0.0 30.00n 0.0 34.89n 0.0 35.00n 0.0 39.89n 0.0 40.00n 0.5 44.89n 0.5 45.00n 0.5 49.89n 0.5 50.00n 0.5 54.89n 0.5 55.00n 0.0 59.89n 0.0 60.00n 0.0 64.89n 0.0 65.00n 0.5 69.89n 0.5 70.00n 0.0 74.89n 0.0 75.00n 0.0 79.89n 0.0 80.00n 0.0 84.89n 0.0 85.00n 0.5 89.89n 0.5 90.00n 0.5 94.89n 0.5 95.00n 0.0 99.89n 0.0 100.00n 0.5 104.89n 0.5 105.00n 0.5 109.89n 0.5 110.00n 0.5 114.89n 0.5 115.00n 0.0 119.89n 0.0 120.00n 0.5 124.89n 0.5 125.00n 0.0 129.89n 0.0 130.00n 0.0 134.89n 0.0 135.00n 0.0 139.89n 0.0 140.00n 0.5 144.89n 0.5 145.00n 0.5 149.89n 0.5 150.00n 0.0 154.89n 0.0 155.00n 0.0 159.89n 0.0 160.00n 0.0 164.89n 0.0 165.00n 0.5 169.89n 0.5 170.00n 0.0 174.89n 0.0 175.00n 0.0 179.89n 0.0 180.00n 0.0 184.89n 0.0 185.00n 0.0 189.89n 0.0 190.00n 0.5 194.89n 0.5 195.00n 0.5 199.89n 0.5 200.00n 0.0 204.89n 0.0 205.00n 0.5 209.89n 0.5 210.00n 0.5 214.89n 0.5 215.00n 0.5 219.89n 0.5 220.00n 0.0 224.89n 0.0 225.00n 0.5 229.89n 0.5 230.00n 0.0 234.89n 0.0 235.00n 0.5 239.89n 0.5 240.00n 0.5 244.89n 0.5 245.00n 0.5 249.89n 0.5)
Va41 A[41] 0 PWL(0.00n 0.0 4.89n 0.0 5.00n 0.5 9.89n 0.5 10.00n 0.0 14.89n 0.0 15.00n 0.5 19.89n 0.5 20.00n 0.5 24.89n 0.5 25.00n 0.5 29.89n 0.5 30.00n 0.0 34.89n 0.0 35.00n 0.0 39.89n 0.0 40.00n 0.0 44.89n 0.0 45.00n 0.5 49.89n 0.5 50.00n 0.5 54.89n 0.5 55.00n 0.5 59.89n 0.5 60.00n 0.0 64.89n 0.0 65.00n 0.0 69.89n 0.0 70.00n 0.5 74.89n 0.5 75.00n 0.0 79.89n 0.0 80.00n 0.0 84.89n 0.0 85.00n 0.0 89.89n 0.0 90.00n 0.5 94.89n 0.5 95.00n 0.5 99.89n 0.5 100.00n 0.0 104.89n 0.0 105.00n 0.5 109.89n 0.5 110.00n 0.5 114.89n 0.5 115.00n 0.5 119.89n 0.5 120.00n 0.0 124.89n 0.0 125.00n 0.5 129.89n 0.5 130.00n 0.0 134.89n 0.0 135.00n 0.0 139.89n 0.0 140.00n 0.0 144.89n 0.0 145.00n 0.5 149.89n 0.5 150.00n 0.5 154.89n 0.5 155.00n 0.0 159.89n 0.0 160.00n 0.0 164.89n 0.0 165.00n 0.0 169.89n 0.0 170.00n 0.5 174.89n 0.5 175.00n 0.0 179.89n 0.0 180.00n 0.0 184.89n 0.0 185.00n 0.0 189.89n 0.0 190.00n 0.0 194.89n 0.0 195.00n 0.5 199.89n 0.5 200.00n 0.5 204.89n 0.5 205.00n 0.0 209.89n 0.0 210.00n 0.5 214.89n 0.5 215.00n 0.5 219.89n 0.5 220.00n 0.5 224.89n 0.5 225.00n 0.0 229.89n 0.0 230.00n 0.5 234.89n 0.5 235.00n 0.0 239.89n 0.0 240.00n 0.5 244.89n 0.5 245.00n 0.5 249.89n 0.5)
Vb41 B[41] 0 PWL(0.00n 0.5 4.89n 0.5 5.00n 0.5 9.89n 0.5 10.00n 0.5 14.89n 0.5 15.00n 0.5 19.89n 0.5 20.00n 0.5 24.89n 0.5 25.00n 0.0 29.89n 0.0 30.00n 0.5 34.89n 0.5 35.00n 0.5 39.89n 0.5 40.00n 0.5 44.89n 0.5 45.00n 0.5 49.89n 0.5 50.00n 0.5 54.89n 0.5 55.00n 0.5 59.89n 0.5 60.00n 0.5 64.89n 0.5 65.00n 0.5 69.89n 0.5 70.00n 0.5 74.89n 0.5 75.00n 0.5 79.89n 0.5 80.00n 0.5 84.89n 0.5 85.00n 0.5 89.89n 0.5 90.00n 0.5 94.89n 0.5 95.00n 0.5 99.89n 0.5 100.00n 0.0 104.89n 0.0 105.00n 0.5 109.89n 0.5 110.00n 0.5 114.89n 0.5 115.00n 0.0 119.89n 0.0 120.00n 0.0 124.89n 0.0 125.00n 0.0 129.89n 0.0 130.00n 0.0 134.89n 0.0 135.00n 0.0 139.89n 0.0 140.00n 0.5 144.89n 0.5 145.00n 0.0 149.89n 0.0 150.00n 0.5 154.89n 0.5 155.00n 0.5 159.89n 0.5 160.00n 0.5 164.89n 0.5 165.00n 0.5 169.89n 0.5 170.00n 0.0 174.89n 0.0 175.00n 0.5 179.89n 0.5 180.00n 0.5 184.89n 0.5 185.00n 0.5 189.89n 0.5 190.00n 0.0 194.89n 0.0 195.00n 0.5 199.89n 0.5 200.00n 0.0 204.89n 0.0 205.00n 0.0 209.89n 0.0 210.00n 0.5 214.89n 0.5 215.00n 0.0 219.89n 0.0 220.00n 0.5 224.89n 0.5 225.00n 0.5 229.89n 0.5 230.00n 0.0 234.89n 0.0 235.00n 0.0 239.89n 0.0 240.00n 0.5 244.89n 0.5 245.00n 0.0 249.89n 0.0)
Va42 A[42] 0 PWL(0.00n 0.5 4.89n 0.5 5.00n 0.5 9.89n 0.5 10.00n 0.5 14.89n 0.5 15.00n 0.5 19.89n 0.5 20.00n 0.5 24.89n 0.5 25.00n 0.5 29.89n 0.5 30.00n 0.0 34.89n 0.0 35.00n 0.5 39.89n 0.5 40.00n 0.5 44.89n 0.5 45.00n 0.5 49.89n 0.5 50.00n 0.5 54.89n 0.5 55.00n 0.5 59.89n 0.5 60.00n 0.5 64.89n 0.5 65.00n 0.5 69.89n 0.5 70.00n 0.5 74.89n 0.5 75.00n 0.5 79.89n 0.5 80.00n 0.5 84.89n 0.5 85.00n 0.5 89.89n 0.5 90.00n 0.5 94.89n 0.5 95.00n 0.5 99.89n 0.5 100.00n 0.5 104.89n 0.5 105.00n 0.0 109.89n 0.0 110.00n 0.5 114.89n 0.5 115.00n 0.5 119.89n 0.5 120.00n 0.0 124.89n 0.0 125.00n 0.0 129.89n 0.0 130.00n 0.0 134.89n 0.0 135.00n 0.0 139.89n 0.0 140.00n 0.0 144.89n 0.0 145.00n 0.5 149.89n 0.5 150.00n 0.0 154.89n 0.0 155.00n 0.5 159.89n 0.5 160.00n 0.5 164.89n 0.5 165.00n 0.5 169.89n 0.5 170.00n 0.5 174.89n 0.5 175.00n 0.0 179.89n 0.0 180.00n 0.5 184.89n 0.5 185.00n 0.5 189.89n 0.5 190.00n 0.5 194.89n 0.5 195.00n 0.0 199.89n 0.0 200.00n 0.5 204.89n 0.5 205.00n 0.0 209.89n 0.0 210.00n 0.0 214.89n 0.0 215.00n 0.5 219.89n 0.5 220.00n 0.0 224.89n 0.0 225.00n 0.5 229.89n 0.5 230.00n 0.5 234.89n 0.5 235.00n 0.0 239.89n 0.0 240.00n 0.0 244.89n 0.0 245.00n 0.5 249.89n 0.5)
Vb42 B[42] 0 PWL(0.00n 0.0 4.89n 0.0 5.00n 0.5 9.89n 0.5 10.00n 0.0 14.89n 0.0 15.00n 0.5 19.89n 0.5 20.00n 0.5 24.89n 0.5 25.00n 0.5 29.89n 0.5 30.00n 0.0 34.89n 0.0 35.00n 0.0 39.89n 0.0 40.00n 0.0 44.89n 0.0 45.00n 0.5 49.89n 0.5 50.00n 0.5 54.89n 0.5 55.00n 0.5 59.89n 0.5 60.00n 0.0 64.89n 0.0 65.00n 0.0 69.89n 0.0 70.00n 0.5 74.89n 0.5 75.00n 0.0 79.89n 0.0 80.00n 0.0 84.89n 0.0 85.00n 0.0 89.89n 0.0 90.00n 0.5 94.89n 0.5 95.00n 0.5 99.89n 0.5 100.00n 0.0 104.89n 0.0 105.00n 0.5 109.89n 0.5 110.00n 0.5 114.89n 0.5 115.00n 0.5 119.89n 0.5 120.00n 0.0 124.89n 0.0 125.00n 0.5 129.89n 0.5 130.00n 0.0 134.89n 0.0 135.00n 0.0 139.89n 0.0 140.00n 0.0 144.89n 0.0 145.00n 0.5 149.89n 0.5 150.00n 0.5 154.89n 0.5 155.00n 0.0 159.89n 0.0 160.00n 0.0 164.89n 0.0 165.00n 0.0 169.89n 0.0 170.00n 0.5 174.89n 0.5 175.00n 0.0 179.89n 0.0 180.00n 0.0 184.89n 0.0 185.00n 0.0 189.89n 0.0 190.00n 0.0 194.89n 0.0 195.00n 0.5 199.89n 0.5 200.00n 0.5 204.89n 0.5 205.00n 0.0 209.89n 0.0 210.00n 0.5 214.89n 0.5 215.00n 0.5 219.89n 0.5 220.00n 0.5 224.89n 0.5 225.00n 0.0 229.89n 0.0 230.00n 0.5 234.89n 0.5 235.00n 0.0 239.89n 0.0 240.00n 0.5 244.89n 0.5 245.00n 0.5 249.89n 0.5)
Va43 A[43] 0 PWL(0.00n 0.5 4.89n 0.5 5.00n 0.0 9.89n 0.0 10.00n 0.5 14.89n 0.5 15.00n 0.0 19.89n 0.0 20.00n 0.5 24.89n 0.5 25.00n 0.5 29.89n 0.5 30.00n 0.5 34.89n 0.5 35.00n 0.0 39.89n 0.0 40.00n 0.0 44.89n 0.0 45.00n 0.0 49.89n 0.0 50.00n 0.5 54.89n 0.5 55.00n 0.5 59.89n 0.5 60.00n 0.5 64.89n 0.5 65.00n 0.0 69.89n 0.0 70.00n 0.0 74.89n 0.0 75.00n 0.5 79.89n 0.5 80.00n 0.0 84.89n 0.0 85.00n 0.0 89.89n 0.0 90.00n 0.0 94.89n 0.0 95.00n 0.5 99.89n 0.5 100.00n 0.5 104.89n 0.5 105.00n 0.0 109.89n 0.0 110.00n 0.5 114.89n 0.5 115.00n 0.5 119.89n 0.5 120.00n 0.5 124.89n 0.5 125.00n 0.0 129.89n 0.0 130.00n 0.5 134.89n 0.5 135.00n 0.0 139.89n 0.0 140.00n 0.0 144.89n 0.0 145.00n 0.0 149.89n 0.0 150.00n 0.5 154.89n 0.5 155.00n 0.5 159.89n 0.5 160.00n 0.0 164.89n 0.0 165.00n 0.0 169.89n 0.0 170.00n 0.0 174.89n 0.0 175.00n 0.5 179.89n 0.5 180.00n 0.0 184.89n 0.0 185.00n 0.0 189.89n 0.0 190.00n 0.0 194.89n 0.0 195.00n 0.0 199.89n 0.0 200.00n 0.5 204.89n 0.5 205.00n 0.5 209.89n 0.5 210.00n 0.0 214.89n 0.0 215.00n 0.5 219.89n 0.5 220.00n 0.5 224.89n 0.5 225.00n 0.5 229.89n 0.5 230.00n 0.0 234.89n 0.0 235.00n 0.5 239.89n 0.5 240.00n 0.0 244.89n 0.0 245.00n 0.5 249.89n 0.5)
Vb43 B[43] 0 PWL(0.00n 0.5 4.89n 0.5 5.00n 0.5 9.89n 0.5 10.00n 0.5 14.89n 0.5 15.00n 0.5 19.89n 0.5 20.00n 0.5 24.89n 0.5 25.00n 0.5 29.89n 0.5 30.00n 0.0 34.89n 0.0 35.00n 0.5 39.89n 0.5 40.00n 0.5 44.89n 0.5 45.00n 0.5 49.89n 0.5 50.00n 0.5 54.89n 0.5 55.00n 0.5 59.89n 0.5 60.00n 0.5 64.89n 0.5 65.00n 0.5 69.89n 0.5 70.00n 0.5 74.89n 0.5 75.00n 0.5 79.89n 0.5 80.00n 0.5 84.89n 0.5 85.00n 0.5 89.89n 0.5 90.00n 0.5 94.89n 0.5 95.00n 0.5 99.89n 0.5 100.00n 0.5 104.89n 0.5 105.00n 0.0 109.89n 0.0 110.00n 0.5 114.89n 0.5 115.00n 0.5 119.89n 0.5 120.00n 0.0 124.89n 0.0 125.00n 0.0 129.89n 0.0 130.00n 0.0 134.89n 0.0 135.00n 0.0 139.89n 0.0 140.00n 0.0 144.89n 0.0 145.00n 0.5 149.89n 0.5 150.00n 0.0 154.89n 0.0 155.00n 0.5 159.89n 0.5 160.00n 0.5 164.89n 0.5 165.00n 0.5 169.89n 0.5 170.00n 0.5 174.89n 0.5 175.00n 0.0 179.89n 0.0 180.00n 0.5 184.89n 0.5 185.00n 0.5 189.89n 0.5 190.00n 0.5 194.89n 0.5 195.00n 0.0 199.89n 0.0 200.00n 0.5 204.89n 0.5 205.00n 0.0 209.89n 0.0 210.00n 0.0 214.89n 0.0 215.00n 0.5 219.89n 0.5 220.00n 0.0 224.89n 0.0 225.00n 0.5 229.89n 0.5 230.00n 0.5 234.89n 0.5 235.00n 0.0 239.89n 0.0 240.00n 0.0 244.89n 0.0 245.00n 0.5 249.89n 0.5)
Va44 A[44] 0 PWL(0.00n 0.5 4.89n 0.5 5.00n 0.5 9.89n 0.5 10.00n 0.5 14.89n 0.5 15.00n 0.5 19.89n 0.5 20.00n 0.5 24.89n 0.5 25.00n 0.5 29.89n 0.5 30.00n 0.5 34.89n 0.5 35.00n 0.0 39.89n 0.0 40.00n 0.5 44.89n 0.5 45.00n 0.5 49.89n 0.5 50.00n 0.5 54.89n 0.5 55.00n 0.5 59.89n 0.5 60.00n 0.5 64.89n 0.5 65.00n 0.5 69.89n 0.5 70.00n 0.5 74.89n 0.5 75.00n 0.5 79.89n 0.5 80.00n 0.5 84.89n 0.5 85.00n 0.5 89.89n 0.5 90.00n 0.5 94.89n 0.5 95.00n 0.5 99.89n 0.5 100.00n 0.5 104.89n 0.5 105.00n 0.5 109.89n 0.5 110.00n 0.0 114.89n 0.0 115.00n 0.5 119.89n 0.5 120.00n 0.5 124.89n 0.5 125.00n 0.0 129.89n 0.0 130.00n 0.0 134.89n 0.0 135.00n 0.0 139.89n 0.0 140.00n 0.0 144.89n 0.0 145.00n 0.0 149.89n 0.0 150.00n 0.5 154.89n 0.5 155.00n 0.0 159.89n 0.0 160.00n 0.5 164.89n 0.5 165.00n 0.5 169.89n 0.5 170.00n 0.5 174.89n 0.5 175.00n 0.5 179.89n 0.5 180.00n 0.0 184.89n 0.0 185.00n 0.5 189.89n 0.5 190.00n 0.5 194.89n 0.5 195.00n 0.5 199.89n 0.5 200.00n 0.0 204.89n 0.0 205.00n 0.5 209.89n 0.5 210.00n 0.0 214.89n 0.0 215.00n 0.0 219.89n 0.0 220.00n 0.5 224.89n 0.5 225.00n 0.0 229.89n 0.0 230.00n 0.5 234.89n 0.5 235.00n 0.5 239.89n 0.5 240.00n 0.0 244.89n 0.0 245.00n 0.0 249.89n 0.0)
Vb44 B[44] 0 PWL(0.00n 0.5 4.89n 0.5 5.00n 0.0 9.89n 0.0 10.00n 0.5 14.89n 0.5 15.00n 0.0 19.89n 0.0 20.00n 0.5 24.89n 0.5 25.00n 0.5 29.89n 0.5 30.00n 0.5 34.89n 0.5 35.00n 0.0 39.89n 0.0 40.00n 0.0 44.89n 0.0 45.00n 0.0 49.89n 0.0 50.00n 0.5 54.89n 0.5 55.00n 0.5 59.89n 0.5 60.00n 0.5 64.89n 0.5 65.00n 0.0 69.89n 0.0 70.00n 0.0 74.89n 0.0 75.00n 0.5 79.89n 0.5 80.00n 0.0 84.89n 0.0 85.00n 0.0 89.89n 0.0 90.00n 0.0 94.89n 0.0 95.00n 0.5 99.89n 0.5 100.00n 0.5 104.89n 0.5 105.00n 0.0 109.89n 0.0 110.00n 0.5 114.89n 0.5 115.00n 0.5 119.89n 0.5 120.00n 0.5 124.89n 0.5 125.00n 0.0 129.89n 0.0 130.00n 0.5 134.89n 0.5 135.00n 0.0 139.89n 0.0 140.00n 0.0 144.89n 0.0 145.00n 0.0 149.89n 0.0 150.00n 0.5 154.89n 0.5 155.00n 0.5 159.89n 0.5 160.00n 0.0 164.89n 0.0 165.00n 0.0 169.89n 0.0 170.00n 0.0 174.89n 0.0 175.00n 0.5 179.89n 0.5 180.00n 0.0 184.89n 0.0 185.00n 0.0 189.89n 0.0 190.00n 0.0 194.89n 0.0 195.00n 0.0 199.89n 0.0 200.00n 0.5 204.89n 0.5 205.00n 0.5 209.89n 0.5 210.00n 0.0 214.89n 0.0 215.00n 0.5 219.89n 0.5 220.00n 0.5 224.89n 0.5 225.00n 0.5 229.89n 0.5 230.00n 0.0 234.89n 0.0 235.00n 0.5 239.89n 0.5 240.00n 0.0 244.89n 0.0 245.00n 0.5 249.89n 0.5)
Va45 A[45] 0 PWL(0.00n 0.5 4.89n 0.5 5.00n 0.5 9.89n 0.5 10.00n 0.0 14.89n 0.0 15.00n 0.5 19.89n 0.5 20.00n 0.0 24.89n 0.0 25.00n 0.5 29.89n 0.5 30.00n 0.5 34.89n 0.5 35.00n 0.5 39.89n 0.5 40.00n 0.0 44.89n 0.0 45.00n 0.0 49.89n 0.0 50.00n 0.0 54.89n 0.0 55.00n 0.5 59.89n 0.5 60.00n 0.5 64.89n 0.5 65.00n 0.5 69.89n 0.5 70.00n 0.0 74.89n 0.0 75.00n 0.0 79.89n 0.0 80.00n 0.5 84.89n 0.5 85.00n 0.0 89.89n 0.0 90.00n 0.0 94.89n 0.0 95.00n 0.0 99.89n 0.0 100.00n 0.5 104.89n 0.5 105.00n 0.5 109.89n 0.5 110.00n 0.0 114.89n 0.0 115.00n 0.5 119.89n 0.5 120.00n 0.5 124.89n 0.5 125.00n 0.5 129.89n 0.5 130.00n 0.0 134.89n 0.0 135.00n 0.5 139.89n 0.5 140.00n 0.0 144.89n 0.0 145.00n 0.0 149.89n 0.0 150.00n 0.0 154.89n 0.0 155.00n 0.5 159.89n 0.5 160.00n 0.5 164.89n 0.5 165.00n 0.0 169.89n 0.0 170.00n 0.0 174.89n 0.0 175.00n 0.0 179.89n 0.0 180.00n 0.5 184.89n 0.5 185.00n 0.0 189.89n 0.0 190.00n 0.0 194.89n 0.0 195.00n 0.0 199.89n 0.0 200.00n 0.0 204.89n 0.0 205.00n 0.5 209.89n 0.5 210.00n 0.5 214.89n 0.5 215.00n 0.0 219.89n 0.0 220.00n 0.5 224.89n 0.5 225.00n 0.5 229.89n 0.5 230.00n 0.5 234.89n 0.5 235.00n 0.0 239.89n 0.0 240.00n 0.5 244.89n 0.5 245.00n 0.0 249.89n 0.0)
Vb45 B[45] 0 PWL(0.00n 0.5 4.89n 0.5 5.00n 0.5 9.89n 0.5 10.00n 0.5 14.89n 0.5 15.00n 0.5 19.89n 0.5 20.00n 0.5 24.89n 0.5 25.00n 0.5 29.89n 0.5 30.00n 0.5 34.89n 0.5 35.00n 0.0 39.89n 0.0 40.00n 0.5 44.89n 0.5 45.00n 0.5 49.89n 0.5 50.00n 0.5 54.89n 0.5 55.00n 0.5 59.89n 0.5 60.00n 0.5 64.89n 0.5 65.00n 0.5 69.89n 0.5 70.00n 0.5 74.89n 0.5 75.00n 0.5 79.89n 0.5 80.00n 0.5 84.89n 0.5 85.00n 0.5 89.89n 0.5 90.00n 0.5 94.89n 0.5 95.00n 0.5 99.89n 0.5 100.00n 0.5 104.89n 0.5 105.00n 0.5 109.89n 0.5 110.00n 0.0 114.89n 0.0 115.00n 0.5 119.89n 0.5 120.00n 0.5 124.89n 0.5 125.00n 0.0 129.89n 0.0 130.00n 0.0 134.89n 0.0 135.00n 0.0 139.89n 0.0 140.00n 0.0 144.89n 0.0 145.00n 0.0 149.89n 0.0 150.00n 0.5 154.89n 0.5 155.00n 0.0 159.89n 0.0 160.00n 0.5 164.89n 0.5 165.00n 0.5 169.89n 0.5 170.00n 0.5 174.89n 0.5 175.00n 0.5 179.89n 0.5 180.00n 0.0 184.89n 0.0 185.00n 0.5 189.89n 0.5 190.00n 0.5 194.89n 0.5 195.00n 0.5 199.89n 0.5 200.00n 0.0 204.89n 0.0 205.00n 0.5 209.89n 0.5 210.00n 0.0 214.89n 0.0 215.00n 0.0 219.89n 0.0 220.00n 0.5 224.89n 0.5 225.00n 0.0 229.89n 0.0 230.00n 0.5 234.89n 0.5 235.00n 0.5 239.89n 0.5 240.00n 0.0 244.89n 0.0 245.00n 0.0 249.89n 0.0)
Va46 A[46] 0 PWL(0.00n 0.5 4.89n 0.5 5.00n 0.5 9.89n 0.5 10.00n 0.5 14.89n 0.5 15.00n 0.5 19.89n 0.5 20.00n 0.5 24.89n 0.5 25.00n 0.5 29.89n 0.5 30.00n 0.5 34.89n 0.5 35.00n 0.5 39.89n 0.5 40.00n 0.0 44.89n 0.0 45.00n 0.5 49.89n 0.5 50.00n 0.5 54.89n 0.5 55.00n 0.5 59.89n 0.5 60.00n 0.5 64.89n 0.5 65.00n 0.5 69.89n 0.5 70.00n 0.5 74.89n 0.5 75.00n 0.5 79.89n 0.5 80.00n 0.5 84.89n 0.5 85.00n 0.5 89.89n 0.5 90.00n 0.5 94.89n 0.5 95.00n 0.5 99.89n 0.5 100.00n 0.5 104.89n 0.5 105.00n 0.5 109.89n 0.5 110.00n 0.5 114.89n 0.5 115.00n 0.0 119.89n 0.0 120.00n 0.5 124.89n 0.5 125.00n 0.5 129.89n 0.5 130.00n 0.0 134.89n 0.0 135.00n 0.0 139.89n 0.0 140.00n 0.0 144.89n 0.0 145.00n 0.0 149.89n 0.0 150.00n 0.0 154.89n 0.0 155.00n 0.5 159.89n 0.5 160.00n 0.0 164.89n 0.0 165.00n 0.5 169.89n 0.5 170.00n 0.5 174.89n 0.5 175.00n 0.5 179.89n 0.5 180.00n 0.5 184.89n 0.5 185.00n 0.0 189.89n 0.0 190.00n 0.5 194.89n 0.5 195.00n 0.5 199.89n 0.5 200.00n 0.5 204.89n 0.5 205.00n 0.0 209.89n 0.0 210.00n 0.5 214.89n 0.5 215.00n 0.0 219.89n 0.0 220.00n 0.0 224.89n 0.0 225.00n 0.5 229.89n 0.5 230.00n 0.0 234.89n 0.0 235.00n 0.5 239.89n 0.5 240.00n 0.5 244.89n 0.5 245.00n 0.0 249.89n 0.0)
Vb46 B[46] 0 PWL(0.00n 0.5 4.89n 0.5 5.00n 0.5 9.89n 0.5 10.00n 0.0 14.89n 0.0 15.00n 0.5 19.89n 0.5 20.00n 0.0 24.89n 0.0 25.00n 0.5 29.89n 0.5 30.00n 0.5 34.89n 0.5 35.00n 0.5 39.89n 0.5 40.00n 0.0 44.89n 0.0 45.00n 0.0 49.89n 0.0 50.00n 0.0 54.89n 0.0 55.00n 0.5 59.89n 0.5 60.00n 0.5 64.89n 0.5 65.00n 0.5 69.89n 0.5 70.00n 0.0 74.89n 0.0 75.00n 0.0 79.89n 0.0 80.00n 0.5 84.89n 0.5 85.00n 0.0 89.89n 0.0 90.00n 0.0 94.89n 0.0 95.00n 0.0 99.89n 0.0 100.00n 0.5 104.89n 0.5 105.00n 0.5 109.89n 0.5 110.00n 0.0 114.89n 0.0 115.00n 0.5 119.89n 0.5 120.00n 0.5 124.89n 0.5 125.00n 0.5 129.89n 0.5 130.00n 0.0 134.89n 0.0 135.00n 0.5 139.89n 0.5 140.00n 0.0 144.89n 0.0 145.00n 0.0 149.89n 0.0 150.00n 0.0 154.89n 0.0 155.00n 0.5 159.89n 0.5 160.00n 0.5 164.89n 0.5 165.00n 0.0 169.89n 0.0 170.00n 0.0 174.89n 0.0 175.00n 0.0 179.89n 0.0 180.00n 0.5 184.89n 0.5 185.00n 0.0 189.89n 0.0 190.00n 0.0 194.89n 0.0 195.00n 0.0 199.89n 0.0 200.00n 0.0 204.89n 0.0 205.00n 0.5 209.89n 0.5 210.00n 0.5 214.89n 0.5 215.00n 0.0 219.89n 0.0 220.00n 0.5 224.89n 0.5 225.00n 0.5 229.89n 0.5 230.00n 0.5 234.89n 0.5 235.00n 0.0 239.89n 0.0 240.00n 0.5 244.89n 0.5 245.00n 0.0 249.89n 0.0)
Va47 A[47] 0 PWL(0.00n 0.0 4.89n 0.0 5.00n 0.5 9.89n 0.5 10.00n 0.5 14.89n 0.5 15.00n 0.0 19.89n 0.0 20.00n 0.5 24.89n 0.5 25.00n 0.0 29.89n 0.0 30.00n 0.5 34.89n 0.5 35.00n 0.5 39.89n 0.5 40.00n 0.5 44.89n 0.5 45.00n 0.0 49.89n 0.0 50.00n 0.0 54.89n 0.0 55.00n 0.0 59.89n 0.0 60.00n 0.5 64.89n 0.5 65.00n 0.5 69.89n 0.5 70.00n 0.5 74.89n 0.5 75.00n 0.0 79.89n 0.0 80.00n 0.0 84.89n 0.0 85.00n 0.5 89.89n 0.5 90.00n 0.0 94.89n 0.0 95.00n 0.0 99.89n 0.0 100.00n 0.0 104.89n 0.0 105.00n 0.5 109.89n 0.5 110.00n 0.5 114.89n 0.5 115.00n 0.0 119.89n 0.0 120.00n 0.5 124.89n 0.5 125.00n 0.5 129.89n 0.5 130.00n 0.5 134.89n 0.5 135.00n 0.0 139.89n 0.0 140.00n 0.5 144.89n 0.5 145.00n 0.0 149.89n 0.0 150.00n 0.0 154.89n 0.0 155.00n 0.0 159.89n 0.0 160.00n 0.5 164.89n 0.5 165.00n 0.5 169.89n 0.5 170.00n 0.0 174.89n 0.0 175.00n 0.0 179.89n 0.0 180.00n 0.0 184.89n 0.0 185.00n 0.5 189.89n 0.5 190.00n 0.0 194.89n 0.0 195.00n 0.0 199.89n 0.0 200.00n 0.0 204.89n 0.0 205.00n 0.0 209.89n 0.0 210.00n 0.5 214.89n 0.5 215.00n 0.5 219.89n 0.5 220.00n 0.0 224.89n 0.0 225.00n 0.5 229.89n 0.5 230.00n 0.5 234.89n 0.5 235.00n 0.5 239.89n 0.5 240.00n 0.0 244.89n 0.0 245.00n 0.5 249.89n 0.5)
Vb47 B[47] 0 PWL(0.00n 0.5 4.89n 0.5 5.00n 0.5 9.89n 0.5 10.00n 0.5 14.89n 0.5 15.00n 0.5 19.89n 0.5 20.00n 0.5 24.89n 0.5 25.00n 0.5 29.89n 0.5 30.00n 0.5 34.89n 0.5 35.00n 0.5 39.89n 0.5 40.00n 0.0 44.89n 0.0 45.00n 0.5 49.89n 0.5 50.00n 0.5 54.89n 0.5 55.00n 0.5 59.89n 0.5 60.00n 0.5 64.89n 0.5 65.00n 0.5 69.89n 0.5 70.00n 0.5 74.89n 0.5 75.00n 0.5 79.89n 0.5 80.00n 0.5 84.89n 0.5 85.00n 0.5 89.89n 0.5 90.00n 0.5 94.89n 0.5 95.00n 0.5 99.89n 0.5 100.00n 0.5 104.89n 0.5 105.00n 0.5 109.89n 0.5 110.00n 0.5 114.89n 0.5 115.00n 0.0 119.89n 0.0 120.00n 0.5 124.89n 0.5 125.00n 0.5 129.89n 0.5 130.00n 0.0 134.89n 0.0 135.00n 0.0 139.89n 0.0 140.00n 0.0 144.89n 0.0 145.00n 0.0 149.89n 0.0 150.00n 0.0 154.89n 0.0 155.00n 0.5 159.89n 0.5 160.00n 0.0 164.89n 0.0 165.00n 0.5 169.89n 0.5 170.00n 0.5 174.89n 0.5 175.00n 0.5 179.89n 0.5 180.00n 0.5 184.89n 0.5 185.00n 0.0 189.89n 0.0 190.00n 0.5 194.89n 0.5 195.00n 0.5 199.89n 0.5 200.00n 0.5 204.89n 0.5 205.00n 0.0 209.89n 0.0 210.00n 0.5 214.89n 0.5 215.00n 0.0 219.89n 0.0 220.00n 0.0 224.89n 0.0 225.00n 0.5 229.89n 0.5 230.00n 0.0 234.89n 0.0 235.00n 0.5 239.89n 0.5 240.00n 0.5 244.89n 0.5 245.00n 0.0 249.89n 0.0)
Va48 A[48] 0 PWL(0.00n 0.5 4.89n 0.5 5.00n 0.5 9.89n 0.5 10.00n 0.5 14.89n 0.5 15.00n 0.5 19.89n 0.5 20.00n 0.5 24.89n 0.5 25.00n 0.5 29.89n 0.5 30.00n 0.5 34.89n 0.5 35.00n 0.5 39.89n 0.5 40.00n 0.5 44.89n 0.5 45.00n 0.0 49.89n 0.0 50.00n 0.5 54.89n 0.5 55.00n 0.5 59.89n 0.5 60.00n 0.5 64.89n 0.5 65.00n 0.5 69.89n 0.5 70.00n 0.5 74.89n 0.5 75.00n 0.5 79.89n 0.5 80.00n 0.5 84.89n 0.5 85.00n 0.5 89.89n 0.5 90.00n 0.5 94.89n 0.5 95.00n 0.5 99.89n 0.5 100.00n 0.5 104.89n 0.5 105.00n 0.5 109.89n 0.5 110.00n 0.5 114.89n 0.5 115.00n 0.5 119.89n 0.5 120.00n 0.0 124.89n 0.0 125.00n 0.5 129.89n 0.5 130.00n 0.5 134.89n 0.5 135.00n 0.0 139.89n 0.0 140.00n 0.0 144.89n 0.0 145.00n 0.0 149.89n 0.0 150.00n 0.0 154.89n 0.0 155.00n 0.0 159.89n 0.0 160.00n 0.5 164.89n 0.5 165.00n 0.0 169.89n 0.0 170.00n 0.5 174.89n 0.5 175.00n 0.5 179.89n 0.5 180.00n 0.5 184.89n 0.5 185.00n 0.5 189.89n 0.5 190.00n 0.0 194.89n 0.0 195.00n 0.5 199.89n 0.5 200.00n 0.5 204.89n 0.5 205.00n 0.5 209.89n 0.5 210.00n 0.0 214.89n 0.0 215.00n 0.5 219.89n 0.5 220.00n 0.0 224.89n 0.0 225.00n 0.0 229.89n 0.0 230.00n 0.5 234.89n 0.5 235.00n 0.0 239.89n 0.0 240.00n 0.5 244.89n 0.5 245.00n 0.5 249.89n 0.5)
Vb48 B[48] 0 PWL(0.00n 0.0 4.89n 0.0 5.00n 0.5 9.89n 0.5 10.00n 0.5 14.89n 0.5 15.00n 0.0 19.89n 0.0 20.00n 0.5 24.89n 0.5 25.00n 0.0 29.89n 0.0 30.00n 0.5 34.89n 0.5 35.00n 0.5 39.89n 0.5 40.00n 0.5 44.89n 0.5 45.00n 0.0 49.89n 0.0 50.00n 0.0 54.89n 0.0 55.00n 0.0 59.89n 0.0 60.00n 0.5 64.89n 0.5 65.00n 0.5 69.89n 0.5 70.00n 0.5 74.89n 0.5 75.00n 0.0 79.89n 0.0 80.00n 0.0 84.89n 0.0 85.00n 0.5 89.89n 0.5 90.00n 0.0 94.89n 0.0 95.00n 0.0 99.89n 0.0 100.00n 0.0 104.89n 0.0 105.00n 0.5 109.89n 0.5 110.00n 0.5 114.89n 0.5 115.00n 0.0 119.89n 0.0 120.00n 0.5 124.89n 0.5 125.00n 0.5 129.89n 0.5 130.00n 0.5 134.89n 0.5 135.00n 0.0 139.89n 0.0 140.00n 0.5 144.89n 0.5 145.00n 0.0 149.89n 0.0 150.00n 0.0 154.89n 0.0 155.00n 0.0 159.89n 0.0 160.00n 0.5 164.89n 0.5 165.00n 0.5 169.89n 0.5 170.00n 0.0 174.89n 0.0 175.00n 0.0 179.89n 0.0 180.00n 0.0 184.89n 0.0 185.00n 0.5 189.89n 0.5 190.00n 0.0 194.89n 0.0 195.00n 0.0 199.89n 0.0 200.00n 0.0 204.89n 0.0 205.00n 0.0 209.89n 0.0 210.00n 0.5 214.89n 0.5 215.00n 0.5 219.89n 0.5 220.00n 0.0 224.89n 0.0 225.00n 0.5 229.89n 0.5 230.00n 0.5 234.89n 0.5 235.00n 0.5 239.89n 0.5 240.00n 0.0 244.89n 0.0 245.00n 0.5 249.89n 0.5)
Va49 A[49] 0 PWL(0.00n 0.5 4.89n 0.5 5.00n 0.0 9.89n 0.0 10.00n 0.5 14.89n 0.5 15.00n 0.5 19.89n 0.5 20.00n 0.0 24.89n 0.0 25.00n 0.5 29.89n 0.5 30.00n 0.0 34.89n 0.0 35.00n 0.5 39.89n 0.5 40.00n 0.5 44.89n 0.5 45.00n 0.5 49.89n 0.5 50.00n 0.0 54.89n 0.0 55.00n 0.0 59.89n 0.0 60.00n 0.0 64.89n 0.0 65.00n 0.5 69.89n 0.5 70.00n 0.5 74.89n 0.5 75.00n 0.5 79.89n 0.5 80.00n 0.0 84.89n 0.0 85.00n 0.0 89.89n 0.0 90.00n 0.5 94.89n 0.5 95.00n 0.0 99.89n 0.0 100.00n 0.0 104.89n 0.0 105.00n 0.0 109.89n 0.0 110.00n 0.5 114.89n 0.5 115.00n 0.5 119.89n 0.5 120.00n 0.0 124.89n 0.0 125.00n 0.5 129.89n 0.5 130.00n 0.5 134.89n 0.5 135.00n 0.5 139.89n 0.5 140.00n 0.0 144.89n 0.0 145.00n 0.5 149.89n 0.5 150.00n 0.0 154.89n 0.0 155.00n 0.0 159.89n 0.0 160.00n 0.0 164.89n 0.0 165.00n 0.5 169.89n 0.5 170.00n 0.5 174.89n 0.5 175.00n 0.0 179.89n 0.0 180.00n 0.0 184.89n 0.0 185.00n 0.0 189.89n 0.0 190.00n 0.5 194.89n 0.5 195.00n 0.0 199.89n 0.0 200.00n 0.0 204.89n 0.0 205.00n 0.0 209.89n 0.0 210.00n 0.0 214.89n 0.0 215.00n 0.5 219.89n 0.5 220.00n 0.5 224.89n 0.5 225.00n 0.0 229.89n 0.0 230.00n 0.5 234.89n 0.5 235.00n 0.5 239.89n 0.5 240.00n 0.5 244.89n 0.5 245.00n 0.0 249.89n 0.0)
Vb49 B[49] 0 PWL(0.00n 0.5 4.89n 0.5 5.00n 0.5 9.89n 0.5 10.00n 0.5 14.89n 0.5 15.00n 0.5 19.89n 0.5 20.00n 0.5 24.89n 0.5 25.00n 0.5 29.89n 0.5 30.00n 0.5 34.89n 0.5 35.00n 0.5 39.89n 0.5 40.00n 0.5 44.89n 0.5 45.00n 0.0 49.89n 0.0 50.00n 0.5 54.89n 0.5 55.00n 0.5 59.89n 0.5 60.00n 0.5 64.89n 0.5 65.00n 0.5 69.89n 0.5 70.00n 0.5 74.89n 0.5 75.00n 0.5 79.89n 0.5 80.00n 0.5 84.89n 0.5 85.00n 0.5 89.89n 0.5 90.00n 0.5 94.89n 0.5 95.00n 0.5 99.89n 0.5 100.00n 0.5 104.89n 0.5 105.00n 0.5 109.89n 0.5 110.00n 0.5 114.89n 0.5 115.00n 0.5 119.89n 0.5 120.00n 0.0 124.89n 0.0 125.00n 0.5 129.89n 0.5 130.00n 0.5 134.89n 0.5 135.00n 0.0 139.89n 0.0 140.00n 0.0 144.89n 0.0 145.00n 0.0 149.89n 0.0 150.00n 0.0 154.89n 0.0 155.00n 0.0 159.89n 0.0 160.00n 0.5 164.89n 0.5 165.00n 0.0 169.89n 0.0 170.00n 0.5 174.89n 0.5 175.00n 0.5 179.89n 0.5 180.00n 0.5 184.89n 0.5 185.00n 0.5 189.89n 0.5 190.00n 0.0 194.89n 0.0 195.00n 0.5 199.89n 0.5 200.00n 0.5 204.89n 0.5 205.00n 0.5 209.89n 0.5 210.00n 0.0 214.89n 0.0 215.00n 0.5 219.89n 0.5 220.00n 0.0 224.89n 0.0 225.00n 0.0 229.89n 0.0 230.00n 0.5 234.89n 0.5 235.00n 0.0 239.89n 0.0 240.00n 0.5 244.89n 0.5 245.00n 0.5 249.89n 0.5)
Va50 A[50] 0 PWL(0.00n 0.0 4.89n 0.0 5.00n 0.5 9.89n 0.5 10.00n 0.5 14.89n 0.5 15.00n 0.5 19.89n 0.5 20.00n 0.5 24.89n 0.5 25.00n 0.5 29.89n 0.5 30.00n 0.5 34.89n 0.5 35.00n 0.5 39.89n 0.5 40.00n 0.5 44.89n 0.5 45.00n 0.5 49.89n 0.5 50.00n 0.0 54.89n 0.0 55.00n 0.5 59.89n 0.5 60.00n 0.5 64.89n 0.5 65.00n 0.5 69.89n 0.5 70.00n 0.5 74.89n 0.5 75.00n 0.5 79.89n 0.5 80.00n 0.5 84.89n 0.5 85.00n 0.5 89.89n 0.5 90.00n 0.5 94.89n 0.5 95.00n 0.5 99.89n 0.5 100.00n 0.5 104.89n 0.5 105.00n 0.5 109.89n 0.5 110.00n 0.5 114.89n 0.5 115.00n 0.5 119.89n 0.5 120.00n 0.5 124.89n 0.5 125.00n 0.0 129.89n 0.0 130.00n 0.5 134.89n 0.5 135.00n 0.5 139.89n 0.5 140.00n 0.0 144.89n 0.0 145.00n 0.0 149.89n 0.0 150.00n 0.0 154.89n 0.0 155.00n 0.0 159.89n 0.0 160.00n 0.0 164.89n 0.0 165.00n 0.5 169.89n 0.5 170.00n 0.0 174.89n 0.0 175.00n 0.5 179.89n 0.5 180.00n 0.5 184.89n 0.5 185.00n 0.5 189.89n 0.5 190.00n 0.5 194.89n 0.5 195.00n 0.0 199.89n 0.0 200.00n 0.5 204.89n 0.5 205.00n 0.5 209.89n 0.5 210.00n 0.5 214.89n 0.5 215.00n 0.0 219.89n 0.0 220.00n 0.5 224.89n 0.5 225.00n 0.0 229.89n 0.0 230.00n 0.0 234.89n 0.0 235.00n 0.5 239.89n 0.5 240.00n 0.0 244.89n 0.0 245.00n 0.5 249.89n 0.5)
Vb50 B[50] 0 PWL(0.00n 0.5 4.89n 0.5 5.00n 0.0 9.89n 0.0 10.00n 0.5 14.89n 0.5 15.00n 0.5 19.89n 0.5 20.00n 0.0 24.89n 0.0 25.00n 0.5 29.89n 0.5 30.00n 0.0 34.89n 0.0 35.00n 0.5 39.89n 0.5 40.00n 0.5 44.89n 0.5 45.00n 0.5 49.89n 0.5 50.00n 0.0 54.89n 0.0 55.00n 0.0 59.89n 0.0 60.00n 0.0 64.89n 0.0 65.00n 0.5 69.89n 0.5 70.00n 0.5 74.89n 0.5 75.00n 0.5 79.89n 0.5 80.00n 0.0 84.89n 0.0 85.00n 0.0 89.89n 0.0 90.00n 0.5 94.89n 0.5 95.00n 0.0 99.89n 0.0 100.00n 0.0 104.89n 0.0 105.00n 0.0 109.89n 0.0 110.00n 0.5 114.89n 0.5 115.00n 0.5 119.89n 0.5 120.00n 0.0 124.89n 0.0 125.00n 0.5 129.89n 0.5 130.00n 0.5 134.89n 0.5 135.00n 0.5 139.89n 0.5 140.00n 0.0 144.89n 0.0 145.00n 0.5 149.89n 0.5 150.00n 0.0 154.89n 0.0 155.00n 0.0 159.89n 0.0 160.00n 0.0 164.89n 0.0 165.00n 0.5 169.89n 0.5 170.00n 0.5 174.89n 0.5 175.00n 0.0 179.89n 0.0 180.00n 0.0 184.89n 0.0 185.00n 0.0 189.89n 0.0 190.00n 0.5 194.89n 0.5 195.00n 0.0 199.89n 0.0 200.00n 0.0 204.89n 0.0 205.00n 0.0 209.89n 0.0 210.00n 0.0 214.89n 0.0 215.00n 0.5 219.89n 0.5 220.00n 0.5 224.89n 0.5 225.00n 0.0 229.89n 0.0 230.00n 0.5 234.89n 0.5 235.00n 0.5 239.89n 0.5 240.00n 0.5 244.89n 0.5 245.00n 0.0 249.89n 0.0)
Va51 A[51] 0 PWL(0.00n 0.5 4.89n 0.5 5.00n 0.5 9.89n 0.5 10.00n 0.0 14.89n 0.0 15.00n 0.5 19.89n 0.5 20.00n 0.5 24.89n 0.5 25.00n 0.0 29.89n 0.0 30.00n 0.5 34.89n 0.5 35.00n 0.0 39.89n 0.0 40.00n 0.5 44.89n 0.5 45.00n 0.5 49.89n 0.5 50.00n 0.5 54.89n 0.5 55.00n 0.0 59.89n 0.0 60.00n 0.0 64.89n 0.0 65.00n 0.0 69.89n 0.0 70.00n 0.5 74.89n 0.5 75.00n 0.5 79.89n 0.5 80.00n 0.5 84.89n 0.5 85.00n 0.0 89.89n 0.0 90.00n 0.0 94.89n 0.0 95.00n 0.5 99.89n 0.5 100.00n 0.0 104.89n 0.0 105.00n 0.0 109.89n 0.0 110.00n 0.0 114.89n 0.0 115.00n 0.5 119.89n 0.5 120.00n 0.5 124.89n 0.5 125.00n 0.0 129.89n 0.0 130.00n 0.5 134.89n 0.5 135.00n 0.5 139.89n 0.5 140.00n 0.5 144.89n 0.5 145.00n 0.0 149.89n 0.0 150.00n 0.5 154.89n 0.5 155.00n 0.0 159.89n 0.0 160.00n 0.0 164.89n 0.0 165.00n 0.0 169.89n 0.0 170.00n 0.5 174.89n 0.5 175.00n 0.5 179.89n 0.5 180.00n 0.0 184.89n 0.0 185.00n 0.0 189.89n 0.0 190.00n 0.0 194.89n 0.0 195.00n 0.5 199.89n 0.5 200.00n 0.0 204.89n 0.0 205.00n 0.0 209.89n 0.0 210.00n 0.0 214.89n 0.0 215.00n 0.0 219.89n 0.0 220.00n 0.5 224.89n 0.5 225.00n 0.5 229.89n 0.5 230.00n 0.0 234.89n 0.0 235.00n 0.5 239.89n 0.5 240.00n 0.5 244.89n 0.5 245.00n 0.5 249.89n 0.5)
Vb51 B[51] 0 PWL(0.00n 0.0 4.89n 0.0 5.00n 0.5 9.89n 0.5 10.00n 0.5 14.89n 0.5 15.00n 0.5 19.89n 0.5 20.00n 0.5 24.89n 0.5 25.00n 0.5 29.89n 0.5 30.00n 0.5 34.89n 0.5 35.00n 0.5 39.89n 0.5 40.00n 0.5 44.89n 0.5 45.00n 0.5 49.89n 0.5 50.00n 0.0 54.89n 0.0 55.00n 0.5 59.89n 0.5 60.00n 0.5 64.89n 0.5 65.00n 0.5 69.89n 0.5 70.00n 0.5 74.89n 0.5 75.00n 0.5 79.89n 0.5 80.00n 0.5 84.89n 0.5 85.00n 0.5 89.89n 0.5 90.00n 0.5 94.89n 0.5 95.00n 0.5 99.89n 0.5 100.00n 0.5 104.89n 0.5 105.00n 0.5 109.89n 0.5 110.00n 0.5 114.89n 0.5 115.00n 0.5 119.89n 0.5 120.00n 0.5 124.89n 0.5 125.00n 0.0 129.89n 0.0 130.00n 0.5 134.89n 0.5 135.00n 0.5 139.89n 0.5 140.00n 0.0 144.89n 0.0 145.00n 0.0 149.89n 0.0 150.00n 0.0 154.89n 0.0 155.00n 0.0 159.89n 0.0 160.00n 0.0 164.89n 0.0 165.00n 0.5 169.89n 0.5 170.00n 0.0 174.89n 0.0 175.00n 0.5 179.89n 0.5 180.00n 0.5 184.89n 0.5 185.00n 0.5 189.89n 0.5 190.00n 0.5 194.89n 0.5 195.00n 0.0 199.89n 0.0 200.00n 0.5 204.89n 0.5 205.00n 0.5 209.89n 0.5 210.00n 0.5 214.89n 0.5 215.00n 0.0 219.89n 0.0 220.00n 0.5 224.89n 0.5 225.00n 0.0 229.89n 0.0 230.00n 0.0 234.89n 0.0 235.00n 0.5 239.89n 0.5 240.00n 0.0 244.89n 0.0 245.00n 0.5 249.89n 0.5)
Va52 A[52] 0 PWL(0.00n 0.5 4.89n 0.5 5.00n 0.0 9.89n 0.0 10.00n 0.5 14.89n 0.5 15.00n 0.5 19.89n 0.5 20.00n 0.5 24.89n 0.5 25.00n 0.5 29.89n 0.5 30.00n 0.5 34.89n 0.5 35.00n 0.5 39.89n 0.5 40.00n 0.5 44.89n 0.5 45.00n 0.5 49.89n 0.5 50.00n 0.5 54.89n 0.5 55.00n 0.0 59.89n 0.0 60.00n 0.5 64.89n 0.5 65.00n 0.5 69.89n 0.5 70.00n 0.5 74.89n 0.5 75.00n 0.5 79.89n 0.5 80.00n 0.5 84.89n 0.5 85.00n 0.5 89.89n 0.5 90.00n 0.5 94.89n 0.5 95.00n 0.5 99.89n 0.5 100.00n 0.5 104.89n 0.5 105.00n 0.5 109.89n 0.5 110.00n 0.5 114.89n 0.5 115.00n 0.5 119.89n 0.5 120.00n 0.5 124.89n 0.5 125.00n 0.5 129.89n 0.5 130.00n 0.0 134.89n 0.0 135.00n 0.5 139.89n 0.5 140.00n 0.5 144.89n 0.5 145.00n 0.0 149.89n 0.0 150.00n 0.0 154.89n 0.0 155.00n 0.0 159.89n 0.0 160.00n 0.0 164.89n 0.0 165.00n 0.0 169.89n 0.0 170.00n 0.5 174.89n 0.5 175.00n 0.0 179.89n 0.0 180.00n 0.5 184.89n 0.5 185.00n 0.5 189.89n 0.5 190.00n 0.5 194.89n 0.5 195.00n 0.5 199.89n 0.5 200.00n 0.0 204.89n 0.0 205.00n 0.5 209.89n 0.5 210.00n 0.5 214.89n 0.5 215.00n 0.5 219.89n 0.5 220.00n 0.0 224.89n 0.0 225.00n 0.5 229.89n 0.5 230.00n 0.0 234.89n 0.0 235.00n 0.0 239.89n 0.0 240.00n 0.5 244.89n 0.5 245.00n 0.0 249.89n 0.0)
Vb52 B[52] 0 PWL(0.00n 0.5 4.89n 0.5 5.00n 0.5 9.89n 0.5 10.00n 0.0 14.89n 0.0 15.00n 0.5 19.89n 0.5 20.00n 0.5 24.89n 0.5 25.00n 0.0 29.89n 0.0 30.00n 0.5 34.89n 0.5 35.00n 0.0 39.89n 0.0 40.00n 0.5 44.89n 0.5 45.00n 0.5 49.89n 0.5 50.00n 0.5 54.89n 0.5 55.00n 0.0 59.89n 0.0 60.00n 0.0 64.89n 0.0 65.00n 0.0 69.89n 0.0 70.00n 0.5 74.89n 0.5 75.00n 0.5 79.89n 0.5 80.00n 0.5 84.89n 0.5 85.00n 0.0 89.89n 0.0 90.00n 0.0 94.89n 0.0 95.00n 0.5 99.89n 0.5 100.00n 0.0 104.89n 0.0 105.00n 0.0 109.89n 0.0 110.00n 0.0 114.89n 0.0 115.00n 0.5 119.89n 0.5 120.00n 0.5 124.89n 0.5 125.00n 0.0 129.89n 0.0 130.00n 0.5 134.89n 0.5 135.00n 0.5 139.89n 0.5 140.00n 0.5 144.89n 0.5 145.00n 0.0 149.89n 0.0 150.00n 0.5 154.89n 0.5 155.00n 0.0 159.89n 0.0 160.00n 0.0 164.89n 0.0 165.00n 0.0 169.89n 0.0 170.00n 0.5 174.89n 0.5 175.00n 0.5 179.89n 0.5 180.00n 0.0 184.89n 0.0 185.00n 0.0 189.89n 0.0 190.00n 0.0 194.89n 0.0 195.00n 0.5 199.89n 0.5 200.00n 0.0 204.89n 0.0 205.00n 0.0 209.89n 0.0 210.00n 0.0 214.89n 0.0 215.00n 0.0 219.89n 0.0 220.00n 0.5 224.89n 0.5 225.00n 0.5 229.89n 0.5 230.00n 0.0 234.89n 0.0 235.00n 0.5 239.89n 0.5 240.00n 0.5 244.89n 0.5 245.00n 0.5 249.89n 0.5)
Va53 A[53] 0 PWL(0.00n 0.0 4.89n 0.0 5.00n 0.5 9.89n 0.5 10.00n 0.5 14.89n 0.5 15.00n 0.0 19.89n 0.0 20.00n 0.5 24.89n 0.5 25.00n 0.5 29.89n 0.5 30.00n 0.0 34.89n 0.0 35.00n 0.5 39.89n 0.5 40.00n 0.0 44.89n 0.0 45.00n 0.5 49.89n 0.5 50.00n 0.5 54.89n 0.5 55.00n 0.5 59.89n 0.5 60.00n 0.0 64.89n 0.0 65.00n 0.0 69.89n 0.0 70.00n 0.0 74.89n 0.0 75.00n 0.5 79.89n 0.5 80.00n 0.5 84.89n 0.5 85.00n 0.5 89.89n 0.5 90.00n 0.0 94.89n 0.0 95.00n 0.0 99.89n 0.0 100.00n 0.5 104.89n 0.5 105.00n 0.0 109.89n 0.0 110.00n 0.0 114.89n 0.0 115.00n 0.0 119.89n 0.0 120.00n 0.5 124.89n 0.5 125.00n 0.5 129.89n 0.5 130.00n 0.0 134.89n 0.0 135.00n 0.5 139.89n 0.5 140.00n 0.5 144.89n 0.5 145.00n 0.5 149.89n 0.5 150.00n 0.0 154.89n 0.0 155.00n 0.5 159.89n 0.5 160.00n 0.0 164.89n 0.0 165.00n 0.0 169.89n 0.0 170.00n 0.0 174.89n 0.0 175.00n 0.5 179.89n 0.5 180.00n 0.5 184.89n 0.5 185.00n 0.0 189.89n 0.0 190.00n 0.0 194.89n 0.0 195.00n 0.0 199.89n 0.0 200.00n 0.5 204.89n 0.5 205.00n 0.0 209.89n 0.0 210.00n 0.0 214.89n 0.0 215.00n 0.0 219.89n 0.0 220.00n 0.0 224.89n 0.0 225.00n 0.5 229.89n 0.5 230.00n 0.5 234.89n 0.5 235.00n 0.0 239.89n 0.0 240.00n 0.5 244.89n 0.5 245.00n 0.5 249.89n 0.5)
Vb53 B[53] 0 PWL(0.00n 0.5 4.89n 0.5 5.00n 0.0 9.89n 0.0 10.00n 0.5 14.89n 0.5 15.00n 0.5 19.89n 0.5 20.00n 0.5 24.89n 0.5 25.00n 0.5 29.89n 0.5 30.00n 0.5 34.89n 0.5 35.00n 0.5 39.89n 0.5 40.00n 0.5 44.89n 0.5 45.00n 0.5 49.89n 0.5 50.00n 0.5 54.89n 0.5 55.00n 0.0 59.89n 0.0 60.00n 0.5 64.89n 0.5 65.00n 0.5 69.89n 0.5 70.00n 0.5 74.89n 0.5 75.00n 0.5 79.89n 0.5 80.00n 0.5 84.89n 0.5 85.00n 0.5 89.89n 0.5 90.00n 0.5 94.89n 0.5 95.00n 0.5 99.89n 0.5 100.00n 0.5 104.89n 0.5 105.00n 0.5 109.89n 0.5 110.00n 0.5 114.89n 0.5 115.00n 0.5 119.89n 0.5 120.00n 0.5 124.89n 0.5 125.00n 0.5 129.89n 0.5 130.00n 0.0 134.89n 0.0 135.00n 0.5 139.89n 0.5 140.00n 0.5 144.89n 0.5 145.00n 0.0 149.89n 0.0 150.00n 0.0 154.89n 0.0 155.00n 0.0 159.89n 0.0 160.00n 0.0 164.89n 0.0 165.00n 0.0 169.89n 0.0 170.00n 0.5 174.89n 0.5 175.00n 0.0 179.89n 0.0 180.00n 0.5 184.89n 0.5 185.00n 0.5 189.89n 0.5 190.00n 0.5 194.89n 0.5 195.00n 0.5 199.89n 0.5 200.00n 0.0 204.89n 0.0 205.00n 0.5 209.89n 0.5 210.00n 0.5 214.89n 0.5 215.00n 0.5 219.89n 0.5 220.00n 0.0 224.89n 0.0 225.00n 0.5 229.89n 0.5 230.00n 0.0 234.89n 0.0 235.00n 0.0 239.89n 0.0 240.00n 0.5 244.89n 0.5 245.00n 0.0 249.89n 0.0)
Va54 A[54] 0 PWL(0.00n 0.5 4.89n 0.5 5.00n 0.5 9.89n 0.5 10.00n 0.0 14.89n 0.0 15.00n 0.5 19.89n 0.5 20.00n 0.5 24.89n 0.5 25.00n 0.5 29.89n 0.5 30.00n 0.5 34.89n 0.5 35.00n 0.5 39.89n 0.5 40.00n 0.5 44.89n 0.5 45.00n 0.5 49.89n 0.5 50.00n 0.5 54.89n 0.5 55.00n 0.5 59.89n 0.5 60.00n 0.0 64.89n 0.0 65.00n 0.5 69.89n 0.5 70.00n 0.5 74.89n 0.5 75.00n 0.5 79.89n 0.5 80.00n 0.5 84.89n 0.5 85.00n 0.5 89.89n 0.5 90.00n 0.5 94.89n 0.5 95.00n 0.5 99.89n 0.5 100.00n 0.5 104.89n 0.5 105.00n 0.5 109.89n 0.5 110.00n 0.5 114.89n 0.5 115.00n 0.5 119.89n 0.5 120.00n 0.5 124.89n 0.5 125.00n 0.5 129.89n 0.5 130.00n 0.5 134.89n 0.5 135.00n 0.0 139.89n 0.0 140.00n 0.5 144.89n 0.5 145.00n 0.5 149.89n 0.5 150.00n 0.0 154.89n 0.0 155.00n 0.0 159.89n 0.0 160.00n 0.0 164.89n 0.0 165.00n 0.0 169.89n 0.0 170.00n 0.0 174.89n 0.0 175.00n 0.5 179.89n 0.5 180.00n 0.0 184.89n 0.0 185.00n 0.5 189.89n 0.5 190.00n 0.5 194.89n 0.5 195.00n 0.5 199.89n 0.5 200.00n 0.5 204.89n 0.5 205.00n 0.0 209.89n 0.0 210.00n 0.5 214.89n 0.5 215.00n 0.5 219.89n 0.5 220.00n 0.5 224.89n 0.5 225.00n 0.0 229.89n 0.0 230.00n 0.5 234.89n 0.5 235.00n 0.0 239.89n 0.0 240.00n 0.0 244.89n 0.0 245.00n 0.5 249.89n 0.5)
Vb54 B[54] 0 PWL(0.00n 0.0 4.89n 0.0 5.00n 0.5 9.89n 0.5 10.00n 0.5 14.89n 0.5 15.00n 0.0 19.89n 0.0 20.00n 0.5 24.89n 0.5 25.00n 0.5 29.89n 0.5 30.00n 0.0 34.89n 0.0 35.00n 0.5 39.89n 0.5 40.00n 0.0 44.89n 0.0 45.00n 0.5 49.89n 0.5 50.00n 0.5 54.89n 0.5 55.00n 0.5 59.89n 0.5 60.00n 0.0 64.89n 0.0 65.00n 0.0 69.89n 0.0 70.00n 0.0 74.89n 0.0 75.00n 0.5 79.89n 0.5 80.00n 0.5 84.89n 0.5 85.00n 0.5 89.89n 0.5 90.00n 0.0 94.89n 0.0 95.00n 0.0 99.89n 0.0 100.00n 0.5 104.89n 0.5 105.00n 0.0 109.89n 0.0 110.00n 0.0 114.89n 0.0 115.00n 0.0 119.89n 0.0 120.00n 0.5 124.89n 0.5 125.00n 0.5 129.89n 0.5 130.00n 0.0 134.89n 0.0 135.00n 0.5 139.89n 0.5 140.00n 0.5 144.89n 0.5 145.00n 0.5 149.89n 0.5 150.00n 0.0 154.89n 0.0 155.00n 0.5 159.89n 0.5 160.00n 0.0 164.89n 0.0 165.00n 0.0 169.89n 0.0 170.00n 0.0 174.89n 0.0 175.00n 0.5 179.89n 0.5 180.00n 0.5 184.89n 0.5 185.00n 0.0 189.89n 0.0 190.00n 0.0 194.89n 0.0 195.00n 0.0 199.89n 0.0 200.00n 0.5 204.89n 0.5 205.00n 0.0 209.89n 0.0 210.00n 0.0 214.89n 0.0 215.00n 0.0 219.89n 0.0 220.00n 0.0 224.89n 0.0 225.00n 0.5 229.89n 0.5 230.00n 0.5 234.89n 0.5 235.00n 0.0 239.89n 0.0 240.00n 0.5 244.89n 0.5 245.00n 0.5 249.89n 0.5)
Va55 A[55] 0 PWL(0.00n 0.0 4.89n 0.0 5.00n 0.0 9.89n 0.0 10.00n 0.5 14.89n 0.5 15.00n 0.5 19.89n 0.5 20.00n 0.0 24.89n 0.0 25.00n 0.5 29.89n 0.5 30.00n 0.5 34.89n 0.5 35.00n 0.0 39.89n 0.0 40.00n 0.5 44.89n 0.5 45.00n 0.0 49.89n 0.0 50.00n 0.5 54.89n 0.5 55.00n 0.5 59.89n 0.5 60.00n 0.5 64.89n 0.5 65.00n 0.0 69.89n 0.0 70.00n 0.0 74.89n 0.0 75.00n 0.0 79.89n 0.0 80.00n 0.5 84.89n 0.5 85.00n 0.5 89.89n 0.5 90.00n 0.5 94.89n 0.5 95.00n 0.0 99.89n 0.0 100.00n 0.0 104.89n 0.0 105.00n 0.5 109.89n 0.5 110.00n 0.0 114.89n 0.0 115.00n 0.0 119.89n 0.0 120.00n 0.0 124.89n 0.0 125.00n 0.5 129.89n 0.5 130.00n 0.5 134.89n 0.5 135.00n 0.0 139.89n 0.0 140.00n 0.5 144.89n 0.5 145.00n 0.5 149.89n 0.5 150.00n 0.5 154.89n 0.5 155.00n 0.0 159.89n 0.0 160.00n 0.5 164.89n 0.5 165.00n 0.0 169.89n 0.0 170.00n 0.0 174.89n 0.0 175.00n 0.0 179.89n 0.0 180.00n 0.5 184.89n 0.5 185.00n 0.5 189.89n 0.5 190.00n 0.0 194.89n 0.0 195.00n 0.0 199.89n 0.0 200.00n 0.0 204.89n 0.0 205.00n 0.5 209.89n 0.5 210.00n 0.0 214.89n 0.0 215.00n 0.0 219.89n 0.0 220.00n 0.0 224.89n 0.0 225.00n 0.0 229.89n 0.0 230.00n 0.5 234.89n 0.5 235.00n 0.5 239.89n 0.5 240.00n 0.0 244.89n 0.0 245.00n 0.5 249.89n 0.5)
Vb55 B[55] 0 PWL(0.00n 0.5 4.89n 0.5 5.00n 0.5 9.89n 0.5 10.00n 0.0 14.89n 0.0 15.00n 0.5 19.89n 0.5 20.00n 0.5 24.89n 0.5 25.00n 0.5 29.89n 0.5 30.00n 0.5 34.89n 0.5 35.00n 0.5 39.89n 0.5 40.00n 0.5 44.89n 0.5 45.00n 0.5 49.89n 0.5 50.00n 0.5 54.89n 0.5 55.00n 0.5 59.89n 0.5 60.00n 0.0 64.89n 0.0 65.00n 0.5 69.89n 0.5 70.00n 0.5 74.89n 0.5 75.00n 0.5 79.89n 0.5 80.00n 0.5 84.89n 0.5 85.00n 0.5 89.89n 0.5 90.00n 0.5 94.89n 0.5 95.00n 0.5 99.89n 0.5 100.00n 0.5 104.89n 0.5 105.00n 0.5 109.89n 0.5 110.00n 0.5 114.89n 0.5 115.00n 0.5 119.89n 0.5 120.00n 0.5 124.89n 0.5 125.00n 0.5 129.89n 0.5 130.00n 0.5 134.89n 0.5 135.00n 0.0 139.89n 0.0 140.00n 0.5 144.89n 0.5 145.00n 0.5 149.89n 0.5 150.00n 0.0 154.89n 0.0 155.00n 0.0 159.89n 0.0 160.00n 0.0 164.89n 0.0 165.00n 0.0 169.89n 0.0 170.00n 0.0 174.89n 0.0 175.00n 0.5 179.89n 0.5 180.00n 0.0 184.89n 0.0 185.00n 0.5 189.89n 0.5 190.00n 0.5 194.89n 0.5 195.00n 0.5 199.89n 0.5 200.00n 0.5 204.89n 0.5 205.00n 0.0 209.89n 0.0 210.00n 0.5 214.89n 0.5 215.00n 0.5 219.89n 0.5 220.00n 0.5 224.89n 0.5 225.00n 0.0 229.89n 0.0 230.00n 0.5 234.89n 0.5 235.00n 0.0 239.89n 0.0 240.00n 0.0 244.89n 0.0 245.00n 0.5 249.89n 0.5)
Va56 A[56] 0 PWL(0.00n 0.5 4.89n 0.5 5.00n 0.5 9.89n 0.5 10.00n 0.5 14.89n 0.5 15.00n 0.0 19.89n 0.0 20.00n 0.5 24.89n 0.5 25.00n 0.5 29.89n 0.5 30.00n 0.5 34.89n 0.5 35.00n 0.5 39.89n 0.5 40.00n 0.5 44.89n 0.5 45.00n 0.5 49.89n 0.5 50.00n 0.5 54.89n 0.5 55.00n 0.5 59.89n 0.5 60.00n 0.5 64.89n 0.5 65.00n 0.0 69.89n 0.0 70.00n 0.5 74.89n 0.5 75.00n 0.5 79.89n 0.5 80.00n 0.5 84.89n 0.5 85.00n 0.5 89.89n 0.5 90.00n 0.5 94.89n 0.5 95.00n 0.5 99.89n 0.5 100.00n 0.5 104.89n 0.5 105.00n 0.5 109.89n 0.5 110.00n 0.5 114.89n 0.5 115.00n 0.5 119.89n 0.5 120.00n 0.5 124.89n 0.5 125.00n 0.5 129.89n 0.5 130.00n 0.5 134.89n 0.5 135.00n 0.5 139.89n 0.5 140.00n 0.0 144.89n 0.0 145.00n 0.5 149.89n 0.5 150.00n 0.5 154.89n 0.5 155.00n 0.0 159.89n 0.0 160.00n 0.0 164.89n 0.0 165.00n 0.0 169.89n 0.0 170.00n 0.0 174.89n 0.0 175.00n 0.0 179.89n 0.0 180.00n 0.5 184.89n 0.5 185.00n 0.0 189.89n 0.0 190.00n 0.5 194.89n 0.5 195.00n 0.5 199.89n 0.5 200.00n 0.5 204.89n 0.5 205.00n 0.5 209.89n 0.5 210.00n 0.0 214.89n 0.0 215.00n 0.5 219.89n 0.5 220.00n 0.5 224.89n 0.5 225.00n 0.5 229.89n 0.5 230.00n 0.0 234.89n 0.0 235.00n 0.5 239.89n 0.5 240.00n 0.0 244.89n 0.0 245.00n 0.0 249.89n 0.0)
Vb56 B[56] 0 PWL(0.00n 0.0 4.89n 0.0 5.00n 0.0 9.89n 0.0 10.00n 0.5 14.89n 0.5 15.00n 0.5 19.89n 0.5 20.00n 0.0 24.89n 0.0 25.00n 0.5 29.89n 0.5 30.00n 0.5 34.89n 0.5 35.00n 0.0 39.89n 0.0 40.00n 0.5 44.89n 0.5 45.00n 0.0 49.89n 0.0 50.00n 0.5 54.89n 0.5 55.00n 0.5 59.89n 0.5 60.00n 0.5 64.89n 0.5 65.00n 0.0 69.89n 0.0 70.00n 0.0 74.89n 0.0 75.00n 0.0 79.89n 0.0 80.00n 0.5 84.89n 0.5 85.00n 0.5 89.89n 0.5 90.00n 0.5 94.89n 0.5 95.00n 0.0 99.89n 0.0 100.00n 0.0 104.89n 0.0 105.00n 0.5 109.89n 0.5 110.00n 0.0 114.89n 0.0 115.00n 0.0 119.89n 0.0 120.00n 0.0 124.89n 0.0 125.00n 0.5 129.89n 0.5 130.00n 0.5 134.89n 0.5 135.00n 0.0 139.89n 0.0 140.00n 0.5 144.89n 0.5 145.00n 0.5 149.89n 0.5 150.00n 0.5 154.89n 0.5 155.00n 0.0 159.89n 0.0 160.00n 0.5 164.89n 0.5 165.00n 0.0 169.89n 0.0 170.00n 0.0 174.89n 0.0 175.00n 0.0 179.89n 0.0 180.00n 0.5 184.89n 0.5 185.00n 0.5 189.89n 0.5 190.00n 0.0 194.89n 0.0 195.00n 0.0 199.89n 0.0 200.00n 0.0 204.89n 0.0 205.00n 0.5 209.89n 0.5 210.00n 0.0 214.89n 0.0 215.00n 0.0 219.89n 0.0 220.00n 0.0 224.89n 0.0 225.00n 0.0 229.89n 0.0 230.00n 0.5 234.89n 0.5 235.00n 0.5 239.89n 0.5 240.00n 0.0 244.89n 0.0 245.00n 0.5 249.89n 0.5)
Va57 A[57] 0 PWL(0.00n 0.0 4.89n 0.0 5.00n 0.0 9.89n 0.0 10.00n 0.0 14.89n 0.0 15.00n 0.5 19.89n 0.5 20.00n 0.5 24.89n 0.5 25.00n 0.0 29.89n 0.0 30.00n 0.5 34.89n 0.5 35.00n 0.5 39.89n 0.5 40.00n 0.0 44.89n 0.0 45.00n 0.5 49.89n 0.5 50.00n 0.0 54.89n 0.0 55.00n 0.5 59.89n 0.5 60.00n 0.5 64.89n 0.5 65.00n 0.5 69.89n 0.5 70.00n 0.0 74.89n 0.0 75.00n 0.0 79.89n 0.0 80.00n 0.0 84.89n 0.0 85.00n 0.5 89.89n 0.5 90.00n 0.5 94.89n 0.5 95.00n 0.5 99.89n 0.5 100.00n 0.0 104.89n 0.0 105.00n 0.0 109.89n 0.0 110.00n 0.5 114.89n 0.5 115.00n 0.0 119.89n 0.0 120.00n 0.0 124.89n 0.0 125.00n 0.0 129.89n 0.0 130.00n 0.5 134.89n 0.5 135.00n 0.5 139.89n 0.5 140.00n 0.0 144.89n 0.0 145.00n 0.5 149.89n 0.5 150.00n 0.5 154.89n 0.5 155.00n 0.5 159.89n 0.5 160.00n 0.0 164.89n 0.0 165.00n 0.5 169.89n 0.5 170.00n 0.0 174.89n 0.0 175.00n 0.0 179.89n 0.0 180.00n 0.0 184.89n 0.0 185.00n 0.5 189.89n 0.5 190.00n 0.5 194.89n 0.5 195.00n 0.0 199.89n 0.0 200.00n 0.0 204.89n 0.0 205.00n 0.0 209.89n 0.0 210.00n 0.5 214.89n 0.5 215.00n 0.0 219.89n 0.0 220.00n 0.0 224.89n 0.0 225.00n 0.0 229.89n 0.0 230.00n 0.0 234.89n 0.0 235.00n 0.5 239.89n 0.5 240.00n 0.5 244.89n 0.5 245.00n 0.0 249.89n 0.0)
Vb57 B[57] 0 PWL(0.00n 0.5 4.89n 0.5 5.00n 0.5 9.89n 0.5 10.00n 0.5 14.89n 0.5 15.00n 0.0 19.89n 0.0 20.00n 0.5 24.89n 0.5 25.00n 0.5 29.89n 0.5 30.00n 0.5 34.89n 0.5 35.00n 0.5 39.89n 0.5 40.00n 0.5 44.89n 0.5 45.00n 0.5 49.89n 0.5 50.00n 0.5 54.89n 0.5 55.00n 0.5 59.89n 0.5 60.00n 0.5 64.89n 0.5 65.00n 0.0 69.89n 0.0 70.00n 0.5 74.89n 0.5 75.00n 0.5 79.89n 0.5 80.00n 0.5 84.89n 0.5 85.00n 0.5 89.89n 0.5 90.00n 0.5 94.89n 0.5 95.00n 0.5 99.89n 0.5 100.00n 0.5 104.89n 0.5 105.00n 0.5 109.89n 0.5 110.00n 0.5 114.89n 0.5 115.00n 0.5 119.89n 0.5 120.00n 0.5 124.89n 0.5 125.00n 0.5 129.89n 0.5 130.00n 0.5 134.89n 0.5 135.00n 0.5 139.89n 0.5 140.00n 0.0 144.89n 0.0 145.00n 0.5 149.89n 0.5 150.00n 0.5 154.89n 0.5 155.00n 0.0 159.89n 0.0 160.00n 0.0 164.89n 0.0 165.00n 0.0 169.89n 0.0 170.00n 0.0 174.89n 0.0 175.00n 0.0 179.89n 0.0 180.00n 0.5 184.89n 0.5 185.00n 0.0 189.89n 0.0 190.00n 0.5 194.89n 0.5 195.00n 0.5 199.89n 0.5 200.00n 0.5 204.89n 0.5 205.00n 0.5 209.89n 0.5 210.00n 0.0 214.89n 0.0 215.00n 0.5 219.89n 0.5 220.00n 0.5 224.89n 0.5 225.00n 0.5 229.89n 0.5 230.00n 0.0 234.89n 0.0 235.00n 0.5 239.89n 0.5 240.00n 0.0 244.89n 0.0 245.00n 0.0 249.89n 0.0)
Va58 A[58] 0 PWL(0.00n 0.5 4.89n 0.5 5.00n 0.5 9.89n 0.5 10.00n 0.5 14.89n 0.5 15.00n 0.5 19.89n 0.5 20.00n 0.0 24.89n 0.0 25.00n 0.5 29.89n 0.5 30.00n 0.5 34.89n 0.5 35.00n 0.5 39.89n 0.5 40.00n 0.5 44.89n 0.5 45.00n 0.5 49.89n 0.5 50.00n 0.5 54.89n 0.5 55.00n 0.5 59.89n 0.5 60.00n 0.5 64.89n 0.5 65.00n 0.5 69.89n 0.5 70.00n 0.0 74.89n 0.0 75.00n 0.5 79.89n 0.5 80.00n 0.5 84.89n 0.5 85.00n 0.5 89.89n 0.5 90.00n 0.5 94.89n 0.5 95.00n 0.5 99.89n 0.5 100.00n 0.5 104.89n 0.5 105.00n 0.5 109.89n 0.5 110.00n 0.5 114.89n 0.5 115.00n 0.5 119.89n 0.5 120.00n 0.5 124.89n 0.5 125.00n 0.5 129.89n 0.5 130.00n 0.5 134.89n 0.5 135.00n 0.5 139.89n 0.5 140.00n 0.5 144.89n 0.5 145.00n 0.0 149.89n 0.0 150.00n 0.5 154.89n 0.5 155.00n 0.5 159.89n 0.5 160.00n 0.0 164.89n 0.0 165.00n 0.0 169.89n 0.0 170.00n 0.0 174.89n 0.0 175.00n 0.0 179.89n 0.0 180.00n 0.0 184.89n 0.0 185.00n 0.5 189.89n 0.5 190.00n 0.0 194.89n 0.0 195.00n 0.5 199.89n 0.5 200.00n 0.5 204.89n 0.5 205.00n 0.5 209.89n 0.5 210.00n 0.5 214.89n 0.5 215.00n 0.0 219.89n 0.0 220.00n 0.5 224.89n 0.5 225.00n 0.5 229.89n 0.5 230.00n 0.5 234.89n 0.5 235.00n 0.0 239.89n 0.0 240.00n 0.5 244.89n 0.5 245.00n 0.0 249.89n 0.0)
Vb58 B[58] 0 PWL(0.00n 0.0 4.89n 0.0 5.00n 0.0 9.89n 0.0 10.00n 0.0 14.89n 0.0 15.00n 0.5 19.89n 0.5 20.00n 0.5 24.89n 0.5 25.00n 0.0 29.89n 0.0 30.00n 0.5 34.89n 0.5 35.00n 0.5 39.89n 0.5 40.00n 0.0 44.89n 0.0 45.00n 0.5 49.89n 0.5 50.00n 0.0 54.89n 0.0 55.00n 0.5 59.89n 0.5 60.00n 0.5 64.89n 0.5 65.00n 0.5 69.89n 0.5 70.00n 0.0 74.89n 0.0 75.00n 0.0 79.89n 0.0 80.00n 0.0 84.89n 0.0 85.00n 0.5 89.89n 0.5 90.00n 0.5 94.89n 0.5 95.00n 0.5 99.89n 0.5 100.00n 0.0 104.89n 0.0 105.00n 0.0 109.89n 0.0 110.00n 0.5 114.89n 0.5 115.00n 0.0 119.89n 0.0 120.00n 0.0 124.89n 0.0 125.00n 0.0 129.89n 0.0 130.00n 0.5 134.89n 0.5 135.00n 0.5 139.89n 0.5 140.00n 0.0 144.89n 0.0 145.00n 0.5 149.89n 0.5 150.00n 0.5 154.89n 0.5 155.00n 0.5 159.89n 0.5 160.00n 0.0 164.89n 0.0 165.00n 0.5 169.89n 0.5 170.00n 0.0 174.89n 0.0 175.00n 0.0 179.89n 0.0 180.00n 0.0 184.89n 0.0 185.00n 0.5 189.89n 0.5 190.00n 0.5 194.89n 0.5 195.00n 0.0 199.89n 0.0 200.00n 0.0 204.89n 0.0 205.00n 0.0 209.89n 0.0 210.00n 0.5 214.89n 0.5 215.00n 0.0 219.89n 0.0 220.00n 0.0 224.89n 0.0 225.00n 0.0 229.89n 0.0 230.00n 0.0 234.89n 0.0 235.00n 0.5 239.89n 0.5 240.00n 0.5 244.89n 0.5 245.00n 0.0 249.89n 0.0)
Va59 A[59] 0 PWL(0.00n 0.5 4.89n 0.5 5.00n 0.0 9.89n 0.0 10.00n 0.0 14.89n 0.0 15.00n 0.0 19.89n 0.0 20.00n 0.5 24.89n 0.5 25.00n 0.5 29.89n 0.5 30.00n 0.0 34.89n 0.0 35.00n 0.5 39.89n 0.5 40.00n 0.5 44.89n 0.5 45.00n 0.0 49.89n 0.0 50.00n 0.5 54.89n 0.5 55.00n 0.0 59.89n 0.0 60.00n 0.5 64.89n 0.5 65.00n 0.5 69.89n 0.5 70.00n 0.5 74.89n 0.5 75.00n 0.0 79.89n 0.0 80.00n 0.0 84.89n 0.0 85.00n 0.0 89.89n 0.0 90.00n 0.5 94.89n 0.5 95.00n 0.5 99.89n 0.5 100.00n 0.5 104.89n 0.5 105.00n 0.0 109.89n 0.0 110.00n 0.0 114.89n 0.0 115.00n 0.5 119.89n 0.5 120.00n 0.0 124.89n 0.0 125.00n 0.0 129.89n 0.0 130.00n 0.0 134.89n 0.0 135.00n 0.5 139.89n 0.5 140.00n 0.5 144.89n 0.5 145.00n 0.0 149.89n 0.0 150.00n 0.5 154.89n 0.5 155.00n 0.5 159.89n 0.5 160.00n 0.5 164.89n 0.5 165.00n 0.0 169.89n 0.0 170.00n 0.5 174.89n 0.5 175.00n 0.0 179.89n 0.0 180.00n 0.0 184.89n 0.0 185.00n 0.0 189.89n 0.0 190.00n 0.5 194.89n 0.5 195.00n 0.5 199.89n 0.5 200.00n 0.0 204.89n 0.0 205.00n 0.0 209.89n 0.0 210.00n 0.0 214.89n 0.0 215.00n 0.5 219.89n 0.5 220.00n 0.0 224.89n 0.0 225.00n 0.0 229.89n 0.0 230.00n 0.0 234.89n 0.0 235.00n 0.0 239.89n 0.0 240.00n 0.5 244.89n 0.5 245.00n 0.5 249.89n 0.5)
Vb59 B[59] 0 PWL(0.00n 0.5 4.89n 0.5 5.00n 0.5 9.89n 0.5 10.00n 0.5 14.89n 0.5 15.00n 0.5 19.89n 0.5 20.00n 0.0 24.89n 0.0 25.00n 0.5 29.89n 0.5 30.00n 0.5 34.89n 0.5 35.00n 0.5 39.89n 0.5 40.00n 0.5 44.89n 0.5 45.00n 0.5 49.89n 0.5 50.00n 0.5 54.89n 0.5 55.00n 0.5 59.89n 0.5 60.00n 0.5 64.89n 0.5 65.00n 0.5 69.89n 0.5 70.00n 0.0 74.89n 0.0 75.00n 0.5 79.89n 0.5 80.00n 0.5 84.89n 0.5 85.00n 0.5 89.89n 0.5 90.00n 0.5 94.89n 0.5 95.00n 0.5 99.89n 0.5 100.00n 0.5 104.89n 0.5 105.00n 0.5 109.89n 0.5 110.00n 0.5 114.89n 0.5 115.00n 0.5 119.89n 0.5 120.00n 0.5 124.89n 0.5 125.00n 0.5 129.89n 0.5 130.00n 0.5 134.89n 0.5 135.00n 0.5 139.89n 0.5 140.00n 0.5 144.89n 0.5 145.00n 0.0 149.89n 0.0 150.00n 0.5 154.89n 0.5 155.00n 0.5 159.89n 0.5 160.00n 0.0 164.89n 0.0 165.00n 0.0 169.89n 0.0 170.00n 0.0 174.89n 0.0 175.00n 0.0 179.89n 0.0 180.00n 0.0 184.89n 0.0 185.00n 0.5 189.89n 0.5 190.00n 0.0 194.89n 0.0 195.00n 0.5 199.89n 0.5 200.00n 0.5 204.89n 0.5 205.00n 0.5 209.89n 0.5 210.00n 0.5 214.89n 0.5 215.00n 0.0 219.89n 0.0 220.00n 0.5 224.89n 0.5 225.00n 0.5 229.89n 0.5 230.00n 0.5 234.89n 0.5 235.00n 0.0 239.89n 0.0 240.00n 0.5 244.89n 0.5 245.00n 0.0 249.89n 0.0)
Va60 A[60] 0 PWL(0.00n 0.5 4.89n 0.5 5.00n 0.5 9.89n 0.5 10.00n 0.5 14.89n 0.5 15.00n 0.5 19.89n 0.5 20.00n 0.5 24.89n 0.5 25.00n 0.0 29.89n 0.0 30.00n 0.5 34.89n 0.5 35.00n 0.5 39.89n 0.5 40.00n 0.5 44.89n 0.5 45.00n 0.5 49.89n 0.5 50.00n 0.5 54.89n 0.5 55.00n 0.5 59.89n 0.5 60.00n 0.5 64.89n 0.5 65.00n 0.5 69.89n 0.5 70.00n 0.5 74.89n 0.5 75.00n 0.0 79.89n 0.0 80.00n 0.5 84.89n 0.5 85.00n 0.5 89.89n 0.5 90.00n 0.5 94.89n 0.5 95.00n 0.5 99.89n 0.5 100.00n 0.5 104.89n 0.5 105.00n 0.5 109.89n 0.5 110.00n 0.5 114.89n 0.5 115.00n 0.5 119.89n 0.5 120.00n 0.5 124.89n 0.5 125.00n 0.5 129.89n 0.5 130.00n 0.5 134.89n 0.5 135.00n 0.5 139.89n 0.5 140.00n 0.5 144.89n 0.5 145.00n 0.5 149.89n 0.5 150.00n 0.0 154.89n 0.0 155.00n 0.5 159.89n 0.5 160.00n 0.5 164.89n 0.5 165.00n 0.0 169.89n 0.0 170.00n 0.0 174.89n 0.0 175.00n 0.0 179.89n 0.0 180.00n 0.0 184.89n 0.0 185.00n 0.0 189.89n 0.0 190.00n 0.5 194.89n 0.5 195.00n 0.0 199.89n 0.0 200.00n 0.5 204.89n 0.5 205.00n 0.5 209.89n 0.5 210.00n 0.5 214.89n 0.5 215.00n 0.5 219.89n 0.5 220.00n 0.0 224.89n 0.0 225.00n 0.5 229.89n 0.5 230.00n 0.5 234.89n 0.5 235.00n 0.5 239.89n 0.5 240.00n 0.0 244.89n 0.0 245.00n 0.5 249.89n 0.5)
Vb60 B[60] 0 PWL(0.00n 0.5 4.89n 0.5 5.00n 0.0 9.89n 0.0 10.00n 0.0 14.89n 0.0 15.00n 0.0 19.89n 0.0 20.00n 0.5 24.89n 0.5 25.00n 0.5 29.89n 0.5 30.00n 0.0 34.89n 0.0 35.00n 0.5 39.89n 0.5 40.00n 0.5 44.89n 0.5 45.00n 0.0 49.89n 0.0 50.00n 0.5 54.89n 0.5 55.00n 0.0 59.89n 0.0 60.00n 0.5 64.89n 0.5 65.00n 0.5 69.89n 0.5 70.00n 0.5 74.89n 0.5 75.00n 0.0 79.89n 0.0 80.00n 0.0 84.89n 0.0 85.00n 0.0 89.89n 0.0 90.00n 0.5 94.89n 0.5 95.00n 0.5 99.89n 0.5 100.00n 0.5 104.89n 0.5 105.00n 0.0 109.89n 0.0 110.00n 0.0 114.89n 0.0 115.00n 0.5 119.89n 0.5 120.00n 0.0 124.89n 0.0 125.00n 0.0 129.89n 0.0 130.00n 0.0 134.89n 0.0 135.00n 0.5 139.89n 0.5 140.00n 0.5 144.89n 0.5 145.00n 0.0 149.89n 0.0 150.00n 0.5 154.89n 0.5 155.00n 0.5 159.89n 0.5 160.00n 0.5 164.89n 0.5 165.00n 0.0 169.89n 0.0 170.00n 0.5 174.89n 0.5 175.00n 0.0 179.89n 0.0 180.00n 0.0 184.89n 0.0 185.00n 0.0 189.89n 0.0 190.00n 0.5 194.89n 0.5 195.00n 0.5 199.89n 0.5 200.00n 0.0 204.89n 0.0 205.00n 0.0 209.89n 0.0 210.00n 0.0 214.89n 0.0 215.00n 0.5 219.89n 0.5 220.00n 0.0 224.89n 0.0 225.00n 0.0 229.89n 0.0 230.00n 0.0 234.89n 0.0 235.00n 0.0 239.89n 0.0 240.00n 0.5 244.89n 0.5 245.00n 0.5 249.89n 0.5)
Va61 A[61] 0 PWL(0.00n 0.5 4.89n 0.5 5.00n 0.5 9.89n 0.5 10.00n 0.0 14.89n 0.0 15.00n 0.0 19.89n 0.0 20.00n 0.0 24.89n 0.0 25.00n 0.5 29.89n 0.5 30.00n 0.5 34.89n 0.5 35.00n 0.0 39.89n 0.0 40.00n 0.5 44.89n 0.5 45.00n 0.5 49.89n 0.5 50.00n 0.0 54.89n 0.0 55.00n 0.5 59.89n 0.5 60.00n 0.0 64.89n 0.0 65.00n 0.5 69.89n 0.5 70.00n 0.5 74.89n 0.5 75.00n 0.5 79.89n 0.5 80.00n 0.0 84.89n 0.0 85.00n 0.0 89.89n 0.0 90.00n 0.0 94.89n 0.0 95.00n 0.5 99.89n 0.5 100.00n 0.5 104.89n 0.5 105.00n 0.5 109.89n 0.5 110.00n 0.0 114.89n 0.0 115.00n 0.0 119.89n 0.0 120.00n 0.5 124.89n 0.5 125.00n 0.0 129.89n 0.0 130.00n 0.0 134.89n 0.0 135.00n 0.0 139.89n 0.0 140.00n 0.5 144.89n 0.5 145.00n 0.5 149.89n 0.5 150.00n 0.0 154.89n 0.0 155.00n 0.5 159.89n 0.5 160.00n 0.5 164.89n 0.5 165.00n 0.5 169.89n 0.5 170.00n 0.0 174.89n 0.0 175.00n 0.5 179.89n 0.5 180.00n 0.0 184.89n 0.0 185.00n 0.0 189.89n 0.0 190.00n 0.0 194.89n 0.0 195.00n 0.5 199.89n 0.5 200.00n 0.5 204.89n 0.5 205.00n 0.0 209.89n 0.0 210.00n 0.0 214.89n 0.0 215.00n 0.0 219.89n 0.0 220.00n 0.5 224.89n 0.5 225.00n 0.0 229.89n 0.0 230.00n 0.0 234.89n 0.0 235.00n 0.0 239.89n 0.0 240.00n 0.0 244.89n 0.0 245.00n 0.5 249.89n 0.5)
Vb61 B[61] 0 PWL(0.00n 0.5 4.89n 0.5 5.00n 0.5 9.89n 0.5 10.00n 0.5 14.89n 0.5 15.00n 0.5 19.89n 0.5 20.00n 0.5 24.89n 0.5 25.00n 0.0 29.89n 0.0 30.00n 0.5 34.89n 0.5 35.00n 0.5 39.89n 0.5 40.00n 0.5 44.89n 0.5 45.00n 0.5 49.89n 0.5 50.00n 0.5 54.89n 0.5 55.00n 0.5 59.89n 0.5 60.00n 0.5 64.89n 0.5 65.00n 0.5 69.89n 0.5 70.00n 0.5 74.89n 0.5 75.00n 0.0 79.89n 0.0 80.00n 0.5 84.89n 0.5 85.00n 0.5 89.89n 0.5 90.00n 0.5 94.89n 0.5 95.00n 0.5 99.89n 0.5 100.00n 0.5 104.89n 0.5 105.00n 0.5 109.89n 0.5 110.00n 0.5 114.89n 0.5 115.00n 0.5 119.89n 0.5 120.00n 0.5 124.89n 0.5 125.00n 0.5 129.89n 0.5 130.00n 0.5 134.89n 0.5 135.00n 0.5 139.89n 0.5 140.00n 0.5 144.89n 0.5 145.00n 0.5 149.89n 0.5 150.00n 0.0 154.89n 0.0 155.00n 0.5 159.89n 0.5 160.00n 0.5 164.89n 0.5 165.00n 0.0 169.89n 0.0 170.00n 0.0 174.89n 0.0 175.00n 0.0 179.89n 0.0 180.00n 0.0 184.89n 0.0 185.00n 0.0 189.89n 0.0 190.00n 0.5 194.89n 0.5 195.00n 0.0 199.89n 0.0 200.00n 0.5 204.89n 0.5 205.00n 0.5 209.89n 0.5 210.00n 0.5 214.89n 0.5 215.00n 0.5 219.89n 0.5 220.00n 0.0 224.89n 0.0 225.00n 0.5 229.89n 0.5 230.00n 0.5 234.89n 0.5 235.00n 0.5 239.89n 0.5 240.00n 0.0 244.89n 0.0 245.00n 0.5 249.89n 0.5)
Va62 A[62] 0 PWL(0.00n 0.0 4.89n 0.0 5.00n 0.5 9.89n 0.5 10.00n 0.5 14.89n 0.5 15.00n 0.5 19.89n 0.5 20.00n 0.5 24.89n 0.5 25.00n 0.5 29.89n 0.5 30.00n 0.0 34.89n 0.0 35.00n 0.5 39.89n 0.5 40.00n 0.5 44.89n 0.5 45.00n 0.5 49.89n 0.5 50.00n 0.5 54.89n 0.5 55.00n 0.5 59.89n 0.5 60.00n 0.5 64.89n 0.5 65.00n 0.5 69.89n 0.5 70.00n 0.5 74.89n 0.5 75.00n 0.5 79.89n 0.5 80.00n 0.0 84.89n 0.0 85.00n 0.5 89.89n 0.5 90.00n 0.5 94.89n 0.5 95.00n 0.5 99.89n 0.5 100.00n 0.5 104.89n 0.5 105.00n 0.5 109.89n 0.5 110.00n 0.5 114.89n 0.5 115.00n 0.5 119.89n 0.5 120.00n 0.5 124.89n 0.5 125.00n 0.5 129.89n 0.5 130.00n 0.5 134.89n 0.5 135.00n 0.5 139.89n 0.5 140.00n 0.5 144.89n 0.5 145.00n 0.5 149.89n 0.5 150.00n 0.5 154.89n 0.5 155.00n 0.0 159.89n 0.0 160.00n 0.5 164.89n 0.5 165.00n 0.5 169.89n 0.5 170.00n 0.0 174.89n 0.0 175.00n 0.0 179.89n 0.0 180.00n 0.0 184.89n 0.0 185.00n 0.0 189.89n 0.0 190.00n 0.0 194.89n 0.0 195.00n 0.5 199.89n 0.5 200.00n 0.0 204.89n 0.0 205.00n 0.5 209.89n 0.5 210.00n 0.5 214.89n 0.5 215.00n 0.5 219.89n 0.5 220.00n 0.5 224.89n 0.5 225.00n 0.0 229.89n 0.0 230.00n 0.5 234.89n 0.5 235.00n 0.5 239.89n 0.5 240.00n 0.5 244.89n 0.5 245.00n 0.0 249.89n 0.0)
Vb62 B[62] 0 PWL(0.00n 0.5 4.89n 0.5 5.00n 0.5 9.89n 0.5 10.00n 0.0 14.89n 0.0 15.00n 0.0 19.89n 0.0 20.00n 0.0 24.89n 0.0 25.00n 0.5 29.89n 0.5 30.00n 0.5 34.89n 0.5 35.00n 0.0 39.89n 0.0 40.00n 0.5 44.89n 0.5 45.00n 0.5 49.89n 0.5 50.00n 0.0 54.89n 0.0 55.00n 0.5 59.89n 0.5 60.00n 0.0 64.89n 0.0 65.00n 0.5 69.89n 0.5 70.00n 0.5 74.89n 0.5 75.00n 0.5 79.89n 0.5 80.00n 0.0 84.89n 0.0 85.00n 0.0 89.89n 0.0 90.00n 0.0 94.89n 0.0 95.00n 0.5 99.89n 0.5 100.00n 0.5 104.89n 0.5 105.00n 0.5 109.89n 0.5 110.00n 0.0 114.89n 0.0 115.00n 0.0 119.89n 0.0 120.00n 0.5 124.89n 0.5 125.00n 0.0 129.89n 0.0 130.00n 0.0 134.89n 0.0 135.00n 0.0 139.89n 0.0 140.00n 0.5 144.89n 0.5 145.00n 0.5 149.89n 0.5 150.00n 0.0 154.89n 0.0 155.00n 0.5 159.89n 0.5 160.00n 0.5 164.89n 0.5 165.00n 0.5 169.89n 0.5 170.00n 0.0 174.89n 0.0 175.00n 0.5 179.89n 0.5 180.00n 0.0 184.89n 0.0 185.00n 0.0 189.89n 0.0 190.00n 0.0 194.89n 0.0 195.00n 0.5 199.89n 0.5 200.00n 0.5 204.89n 0.5 205.00n 0.0 209.89n 0.0 210.00n 0.0 214.89n 0.0 215.00n 0.0 219.89n 0.0 220.00n 0.5 224.89n 0.5 225.00n 0.0 229.89n 0.0 230.00n 0.0 234.89n 0.0 235.00n 0.0 239.89n 0.0 240.00n 0.0 244.89n 0.0 245.00n 0.5 249.89n 0.5)
Va63 A[63] 0 PWL(0.00n 0.5 4.89n 0.5 5.00n 0.5 9.89n 0.5 10.00n 0.5 14.89n 0.5 15.00n 0.0 19.89n 0.0 20.00n 0.0 24.89n 0.0 25.00n 0.0 29.89n 0.0 30.00n 0.5 34.89n 0.5 35.00n 0.5 39.89n 0.5 40.00n 0.0 44.89n 0.0 45.00n 0.5 49.89n 0.5 50.00n 0.5 54.89n 0.5 55.00n 0.0 59.89n 0.0 60.00n 0.5 64.89n 0.5 65.00n 0.0 69.89n 0.0 70.00n 0.5 74.89n 0.5 75.00n 0.5 79.89n 0.5 80.00n 0.5 84.89n 0.5 85.00n 0.0 89.89n 0.0 90.00n 0.0 94.89n 0.0 95.00n 0.0 99.89n 0.0 100.00n 0.5 104.89n 0.5 105.00n 0.5 109.89n 0.5 110.00n 0.5 114.89n 0.5 115.00n 0.0 119.89n 0.0 120.00n 0.0 124.89n 0.0 125.00n 0.5 129.89n 0.5 130.00n 0.0 134.89n 0.0 135.00n 0.0 139.89n 0.0 140.00n 0.0 144.89n 0.0 145.00n 0.5 149.89n 0.5 150.00n 0.5 154.89n 0.5 155.00n 0.0 159.89n 0.0 160.00n 0.5 164.89n 0.5 165.00n 0.5 169.89n 0.5 170.00n 0.5 174.89n 0.5 175.00n 0.0 179.89n 0.0 180.00n 0.5 184.89n 0.5 185.00n 0.0 189.89n 0.0 190.00n 0.0 194.89n 0.0 195.00n 0.0 199.89n 0.0 200.00n 0.5 204.89n 0.5 205.00n 0.5 209.89n 0.5 210.00n 0.0 214.89n 0.0 215.00n 0.0 219.89n 0.0 220.00n 0.0 224.89n 0.0 225.00n 0.5 229.89n 0.5 230.00n 0.0 234.89n 0.0 235.00n 0.0 239.89n 0.0 240.00n 0.0 244.89n 0.0 245.00n 0.0 249.89n 0.0)
Vb63 B[63] 0 PWL(0.00n 0.0 4.89n 0.0 5.00n 0.5 9.89n 0.5 10.00n 0.5 14.89n 0.5 15.00n 0.5 19.89n 0.5 20.00n 0.5 24.89n 0.5 25.00n 0.5 29.89n 0.5 30.00n 0.0 34.89n 0.0 35.00n 0.5 39.89n 0.5 40.00n 0.5 44.89n 0.5 45.00n 0.5 49.89n 0.5 50.00n 0.5 54.89n 0.5 55.00n 0.5 59.89n 0.5 60.00n 0.5 64.89n 0.5 65.00n 0.5 69.89n 0.5 70.00n 0.5 74.89n 0.5 75.00n 0.5 79.89n 0.5 80.00n 0.0 84.89n 0.0 85.00n 0.5 89.89n 0.5 90.00n 0.5 94.89n 0.5 95.00n 0.5 99.89n 0.5 100.00n 0.5 104.89n 0.5 105.00n 0.5 109.89n 0.5 110.00n 0.5 114.89n 0.5 115.00n 0.5 119.89n 0.5 120.00n 0.5 124.89n 0.5 125.00n 0.5 129.89n 0.5 130.00n 0.5 134.89n 0.5 135.00n 0.5 139.89n 0.5 140.00n 0.5 144.89n 0.5 145.00n 0.5 149.89n 0.5 150.00n 0.5 154.89n 0.5 155.00n 0.0 159.89n 0.0 160.00n 0.5 164.89n 0.5 165.00n 0.5 169.89n 0.5 170.00n 0.0 174.89n 0.0 175.00n 0.0 179.89n 0.0 180.00n 0.0 184.89n 0.0 185.00n 0.0 189.89n 0.0 190.00n 0.0 194.89n 0.0 195.00n 0.5 199.89n 0.5 200.00n 0.0 204.89n 0.0 205.00n 0.5 209.89n 0.5 210.00n 0.5 214.89n 0.5 215.00n 0.5 219.89n 0.5 220.00n 0.5 224.89n 0.5 225.00n 0.0 229.89n 0.0 230.00n 0.5 234.89n 0.5 235.00n 0.5 239.89n 0.5 240.00n 0.5 244.89n 0.5 245.00n 0.0 249.89n 0.0)

.OPTIONS DEVICE GMIN=1e-12
.OPTIONS TIMEINT RELTOL=5e-3 ABSTOL=1e-6 ERROPTION=1 MINTIMESTEP=1e-18
.OPTIONS NONLIN MAXSTEP=400 NLSTRATEGY=0 SEARCHMETHOD=2
.OPTIONS LOCA STEPPER=0
.TRAN 1p 250.0n

.PRINT TRAN V(hd[0]) V(hd[1]) V(hd[2]) V(hd[3]) V(hd[4]) V(hd[5]) V(hd[6]) I(Vvdd)

.MEASURE TRAN i_avg AVG I(Vvdd) FROM=0n TO=250.0n
.MEASURE TRAN p_avg AVG {V(VDD)*I(Vvdd)} FROM=0n TO=250.0n

.MEASURE TRAN hd0_v0 FIND V(hd[0]) AT=4.0n
.MEASURE TRAN hd1_v0 FIND V(hd[1]) AT=4.0n
.MEASURE TRAN hd2_v0 FIND V(hd[2]) AT=4.0n
.MEASURE TRAN hd3_v0 FIND V(hd[3]) AT=4.0n
.MEASURE TRAN hd4_v0 FIND V(hd[4]) AT=4.0n
.MEASURE TRAN hd5_v0 FIND V(hd[5]) AT=4.0n
.MEASURE TRAN hd6_v0 FIND V(hd[6]) AT=4.0n
.MEASURE TRAN hd0_v1 FIND V(hd[0]) AT=9.0n
.MEASURE TRAN hd1_v1 FIND V(hd[1]) AT=9.0n
.MEASURE TRAN hd2_v1 FIND V(hd[2]) AT=9.0n
.MEASURE TRAN hd3_v1 FIND V(hd[3]) AT=9.0n
.MEASURE TRAN hd4_v1 FIND V(hd[4]) AT=9.0n
.MEASURE TRAN hd5_v1 FIND V(hd[5]) AT=9.0n
.MEASURE TRAN hd6_v1 FIND V(hd[6]) AT=9.0n
.MEASURE TRAN hd0_v2 FIND V(hd[0]) AT=14.0n
.MEASURE TRAN hd1_v2 FIND V(hd[1]) AT=14.0n
.MEASURE TRAN hd2_v2 FIND V(hd[2]) AT=14.0n
.MEASURE TRAN hd3_v2 FIND V(hd[3]) AT=14.0n
.MEASURE TRAN hd4_v2 FIND V(hd[4]) AT=14.0n
.MEASURE TRAN hd5_v2 FIND V(hd[5]) AT=14.0n
.MEASURE TRAN hd6_v2 FIND V(hd[6]) AT=14.0n
.MEASURE TRAN hd0_v3 FIND V(hd[0]) AT=19.0n
.MEASURE TRAN hd1_v3 FIND V(hd[1]) AT=19.0n
.MEASURE TRAN hd2_v3 FIND V(hd[2]) AT=19.0n
.MEASURE TRAN hd3_v3 FIND V(hd[3]) AT=19.0n
.MEASURE TRAN hd4_v3 FIND V(hd[4]) AT=19.0n
.MEASURE TRAN hd5_v3 FIND V(hd[5]) AT=19.0n
.MEASURE TRAN hd6_v3 FIND V(hd[6]) AT=19.0n
.MEASURE TRAN hd0_v4 FIND V(hd[0]) AT=24.0n
.MEASURE TRAN hd1_v4 FIND V(hd[1]) AT=24.0n
.MEASURE TRAN hd2_v4 FIND V(hd[2]) AT=24.0n
.MEASURE TRAN hd3_v4 FIND V(hd[3]) AT=24.0n
.MEASURE TRAN hd4_v4 FIND V(hd[4]) AT=24.0n
.MEASURE TRAN hd5_v4 FIND V(hd[5]) AT=24.0n
.MEASURE TRAN hd6_v4 FIND V(hd[6]) AT=24.0n
.MEASURE TRAN hd0_v5 FIND V(hd[0]) AT=29.0n
.MEASURE TRAN hd1_v5 FIND V(hd[1]) AT=29.0n
.MEASURE TRAN hd2_v5 FIND V(hd[2]) AT=29.0n
.MEASURE TRAN hd3_v5 FIND V(hd[3]) AT=29.0n
.MEASURE TRAN hd4_v5 FIND V(hd[4]) AT=29.0n
.MEASURE TRAN hd5_v5 FIND V(hd[5]) AT=29.0n
.MEASURE TRAN hd6_v5 FIND V(hd[6]) AT=29.0n
.MEASURE TRAN hd0_v6 FIND V(hd[0]) AT=34.0n
.MEASURE TRAN hd1_v6 FIND V(hd[1]) AT=34.0n
.MEASURE TRAN hd2_v6 FIND V(hd[2]) AT=34.0n
.MEASURE TRAN hd3_v6 FIND V(hd[3]) AT=34.0n
.MEASURE TRAN hd4_v6 FIND V(hd[4]) AT=34.0n
.MEASURE TRAN hd5_v6 FIND V(hd[5]) AT=34.0n
.MEASURE TRAN hd6_v6 FIND V(hd[6]) AT=34.0n
.MEASURE TRAN hd0_v7 FIND V(hd[0]) AT=39.0n
.MEASURE TRAN hd1_v7 FIND V(hd[1]) AT=39.0n
.MEASURE TRAN hd2_v7 FIND V(hd[2]) AT=39.0n
.MEASURE TRAN hd3_v7 FIND V(hd[3]) AT=39.0n
.MEASURE TRAN hd4_v7 FIND V(hd[4]) AT=39.0n
.MEASURE TRAN hd5_v7 FIND V(hd[5]) AT=39.0n
.MEASURE TRAN hd6_v7 FIND V(hd[6]) AT=39.0n
.MEASURE TRAN hd0_v8 FIND V(hd[0]) AT=44.0n
.MEASURE TRAN hd1_v8 FIND V(hd[1]) AT=44.0n
.MEASURE TRAN hd2_v8 FIND V(hd[2]) AT=44.0n
.MEASURE TRAN hd3_v8 FIND V(hd[3]) AT=44.0n
.MEASURE TRAN hd4_v8 FIND V(hd[4]) AT=44.0n
.MEASURE TRAN hd5_v8 FIND V(hd[5]) AT=44.0n
.MEASURE TRAN hd6_v8 FIND V(hd[6]) AT=44.0n
.MEASURE TRAN hd0_v9 FIND V(hd[0]) AT=49.0n
.MEASURE TRAN hd1_v9 FIND V(hd[1]) AT=49.0n
.MEASURE TRAN hd2_v9 FIND V(hd[2]) AT=49.0n
.MEASURE TRAN hd3_v9 FIND V(hd[3]) AT=49.0n
.MEASURE TRAN hd4_v9 FIND V(hd[4]) AT=49.0n
.MEASURE TRAN hd5_v9 FIND V(hd[5]) AT=49.0n
.MEASURE TRAN hd6_v9 FIND V(hd[6]) AT=49.0n
.MEASURE TRAN hd0_v10 FIND V(hd[0]) AT=54.0n
.MEASURE TRAN hd1_v10 FIND V(hd[1]) AT=54.0n
.MEASURE TRAN hd2_v10 FIND V(hd[2]) AT=54.0n
.MEASURE TRAN hd3_v10 FIND V(hd[3]) AT=54.0n
.MEASURE TRAN hd4_v10 FIND V(hd[4]) AT=54.0n
.MEASURE TRAN hd5_v10 FIND V(hd[5]) AT=54.0n
.MEASURE TRAN hd6_v10 FIND V(hd[6]) AT=54.0n
.MEASURE TRAN hd0_v11 FIND V(hd[0]) AT=59.0n
.MEASURE TRAN hd1_v11 FIND V(hd[1]) AT=59.0n
.MEASURE TRAN hd2_v11 FIND V(hd[2]) AT=59.0n
.MEASURE TRAN hd3_v11 FIND V(hd[3]) AT=59.0n
.MEASURE TRAN hd4_v11 FIND V(hd[4]) AT=59.0n
.MEASURE TRAN hd5_v11 FIND V(hd[5]) AT=59.0n
.MEASURE TRAN hd6_v11 FIND V(hd[6]) AT=59.0n
.MEASURE TRAN hd0_v12 FIND V(hd[0]) AT=64.0n
.MEASURE TRAN hd1_v12 FIND V(hd[1]) AT=64.0n
.MEASURE TRAN hd2_v12 FIND V(hd[2]) AT=64.0n
.MEASURE TRAN hd3_v12 FIND V(hd[3]) AT=64.0n
.MEASURE TRAN hd4_v12 FIND V(hd[4]) AT=64.0n
.MEASURE TRAN hd5_v12 FIND V(hd[5]) AT=64.0n
.MEASURE TRAN hd6_v12 FIND V(hd[6]) AT=64.0n
.MEASURE TRAN hd0_v13 FIND V(hd[0]) AT=69.0n
.MEASURE TRAN hd1_v13 FIND V(hd[1]) AT=69.0n
.MEASURE TRAN hd2_v13 FIND V(hd[2]) AT=69.0n
.MEASURE TRAN hd3_v13 FIND V(hd[3]) AT=69.0n
.MEASURE TRAN hd4_v13 FIND V(hd[4]) AT=69.0n
.MEASURE TRAN hd5_v13 FIND V(hd[5]) AT=69.0n
.MEASURE TRAN hd6_v13 FIND V(hd[6]) AT=69.0n
.MEASURE TRAN hd0_v14 FIND V(hd[0]) AT=74.0n
.MEASURE TRAN hd1_v14 FIND V(hd[1]) AT=74.0n
.MEASURE TRAN hd2_v14 FIND V(hd[2]) AT=74.0n
.MEASURE TRAN hd3_v14 FIND V(hd[3]) AT=74.0n
.MEASURE TRAN hd4_v14 FIND V(hd[4]) AT=74.0n
.MEASURE TRAN hd5_v14 FIND V(hd[5]) AT=74.0n
.MEASURE TRAN hd6_v14 FIND V(hd[6]) AT=74.0n
.MEASURE TRAN hd0_v15 FIND V(hd[0]) AT=79.0n
.MEASURE TRAN hd1_v15 FIND V(hd[1]) AT=79.0n
.MEASURE TRAN hd2_v15 FIND V(hd[2]) AT=79.0n
.MEASURE TRAN hd3_v15 FIND V(hd[3]) AT=79.0n
.MEASURE TRAN hd4_v15 FIND V(hd[4]) AT=79.0n
.MEASURE TRAN hd5_v15 FIND V(hd[5]) AT=79.0n
.MEASURE TRAN hd6_v15 FIND V(hd[6]) AT=79.0n
.MEASURE TRAN hd0_v16 FIND V(hd[0]) AT=84.0n
.MEASURE TRAN hd1_v16 FIND V(hd[1]) AT=84.0n
.MEASURE TRAN hd2_v16 FIND V(hd[2]) AT=84.0n
.MEASURE TRAN hd3_v16 FIND V(hd[3]) AT=84.0n
.MEASURE TRAN hd4_v16 FIND V(hd[4]) AT=84.0n
.MEASURE TRAN hd5_v16 FIND V(hd[5]) AT=84.0n
.MEASURE TRAN hd6_v16 FIND V(hd[6]) AT=84.0n
.MEASURE TRAN hd0_v17 FIND V(hd[0]) AT=89.0n
.MEASURE TRAN hd1_v17 FIND V(hd[1]) AT=89.0n
.MEASURE TRAN hd2_v17 FIND V(hd[2]) AT=89.0n
.MEASURE TRAN hd3_v17 FIND V(hd[3]) AT=89.0n
.MEASURE TRAN hd4_v17 FIND V(hd[4]) AT=89.0n
.MEASURE TRAN hd5_v17 FIND V(hd[5]) AT=89.0n
.MEASURE TRAN hd6_v17 FIND V(hd[6]) AT=89.0n
.MEASURE TRAN hd0_v18 FIND V(hd[0]) AT=94.0n
.MEASURE TRAN hd1_v18 FIND V(hd[1]) AT=94.0n
.MEASURE TRAN hd2_v18 FIND V(hd[2]) AT=94.0n
.MEASURE TRAN hd3_v18 FIND V(hd[3]) AT=94.0n
.MEASURE TRAN hd4_v18 FIND V(hd[4]) AT=94.0n
.MEASURE TRAN hd5_v18 FIND V(hd[5]) AT=94.0n
.MEASURE TRAN hd6_v18 FIND V(hd[6]) AT=94.0n
.MEASURE TRAN hd0_v19 FIND V(hd[0]) AT=99.0n
.MEASURE TRAN hd1_v19 FIND V(hd[1]) AT=99.0n
.MEASURE TRAN hd2_v19 FIND V(hd[2]) AT=99.0n
.MEASURE TRAN hd3_v19 FIND V(hd[3]) AT=99.0n
.MEASURE TRAN hd4_v19 FIND V(hd[4]) AT=99.0n
.MEASURE TRAN hd5_v19 FIND V(hd[5]) AT=99.0n
.MEASURE TRAN hd6_v19 FIND V(hd[6]) AT=99.0n
.MEASURE TRAN hd0_v20 FIND V(hd[0]) AT=104.0n
.MEASURE TRAN hd1_v20 FIND V(hd[1]) AT=104.0n
.MEASURE TRAN hd2_v20 FIND V(hd[2]) AT=104.0n
.MEASURE TRAN hd3_v20 FIND V(hd[3]) AT=104.0n
.MEASURE TRAN hd4_v20 FIND V(hd[4]) AT=104.0n
.MEASURE TRAN hd5_v20 FIND V(hd[5]) AT=104.0n
.MEASURE TRAN hd6_v20 FIND V(hd[6]) AT=104.0n
.MEASURE TRAN hd0_v21 FIND V(hd[0]) AT=109.0n
.MEASURE TRAN hd1_v21 FIND V(hd[1]) AT=109.0n
.MEASURE TRAN hd2_v21 FIND V(hd[2]) AT=109.0n
.MEASURE TRAN hd3_v21 FIND V(hd[3]) AT=109.0n
.MEASURE TRAN hd4_v21 FIND V(hd[4]) AT=109.0n
.MEASURE TRAN hd5_v21 FIND V(hd[5]) AT=109.0n
.MEASURE TRAN hd6_v21 FIND V(hd[6]) AT=109.0n
.MEASURE TRAN hd0_v22 FIND V(hd[0]) AT=114.0n
.MEASURE TRAN hd1_v22 FIND V(hd[1]) AT=114.0n
.MEASURE TRAN hd2_v22 FIND V(hd[2]) AT=114.0n
.MEASURE TRAN hd3_v22 FIND V(hd[3]) AT=114.0n
.MEASURE TRAN hd4_v22 FIND V(hd[4]) AT=114.0n
.MEASURE TRAN hd5_v22 FIND V(hd[5]) AT=114.0n
.MEASURE TRAN hd6_v22 FIND V(hd[6]) AT=114.0n
.MEASURE TRAN hd0_v23 FIND V(hd[0]) AT=119.0n
.MEASURE TRAN hd1_v23 FIND V(hd[1]) AT=119.0n
.MEASURE TRAN hd2_v23 FIND V(hd[2]) AT=119.0n
.MEASURE TRAN hd3_v23 FIND V(hd[3]) AT=119.0n
.MEASURE TRAN hd4_v23 FIND V(hd[4]) AT=119.0n
.MEASURE TRAN hd5_v23 FIND V(hd[5]) AT=119.0n
.MEASURE TRAN hd6_v23 FIND V(hd[6]) AT=119.0n
.MEASURE TRAN hd0_v24 FIND V(hd[0]) AT=124.0n
.MEASURE TRAN hd1_v24 FIND V(hd[1]) AT=124.0n
.MEASURE TRAN hd2_v24 FIND V(hd[2]) AT=124.0n
.MEASURE TRAN hd3_v24 FIND V(hd[3]) AT=124.0n
.MEASURE TRAN hd4_v24 FIND V(hd[4]) AT=124.0n
.MEASURE TRAN hd5_v24 FIND V(hd[5]) AT=124.0n
.MEASURE TRAN hd6_v24 FIND V(hd[6]) AT=124.0n
.MEASURE TRAN hd0_v25 FIND V(hd[0]) AT=129.0n
.MEASURE TRAN hd1_v25 FIND V(hd[1]) AT=129.0n
.MEASURE TRAN hd2_v25 FIND V(hd[2]) AT=129.0n
.MEASURE TRAN hd3_v25 FIND V(hd[3]) AT=129.0n
.MEASURE TRAN hd4_v25 FIND V(hd[4]) AT=129.0n
.MEASURE TRAN hd5_v25 FIND V(hd[5]) AT=129.0n
.MEASURE TRAN hd6_v25 FIND V(hd[6]) AT=129.0n
.MEASURE TRAN hd0_v26 FIND V(hd[0]) AT=134.0n
.MEASURE TRAN hd1_v26 FIND V(hd[1]) AT=134.0n
.MEASURE TRAN hd2_v26 FIND V(hd[2]) AT=134.0n
.MEASURE TRAN hd3_v26 FIND V(hd[3]) AT=134.0n
.MEASURE TRAN hd4_v26 FIND V(hd[4]) AT=134.0n
.MEASURE TRAN hd5_v26 FIND V(hd[5]) AT=134.0n
.MEASURE TRAN hd6_v26 FIND V(hd[6]) AT=134.0n
.MEASURE TRAN hd0_v27 FIND V(hd[0]) AT=139.0n
.MEASURE TRAN hd1_v27 FIND V(hd[1]) AT=139.0n
.MEASURE TRAN hd2_v27 FIND V(hd[2]) AT=139.0n
.MEASURE TRAN hd3_v27 FIND V(hd[3]) AT=139.0n
.MEASURE TRAN hd4_v27 FIND V(hd[4]) AT=139.0n
.MEASURE TRAN hd5_v27 FIND V(hd[5]) AT=139.0n
.MEASURE TRAN hd6_v27 FIND V(hd[6]) AT=139.0n
.MEASURE TRAN hd0_v28 FIND V(hd[0]) AT=144.0n
.MEASURE TRAN hd1_v28 FIND V(hd[1]) AT=144.0n
.MEASURE TRAN hd2_v28 FIND V(hd[2]) AT=144.0n
.MEASURE TRAN hd3_v28 FIND V(hd[3]) AT=144.0n
.MEASURE TRAN hd4_v28 FIND V(hd[4]) AT=144.0n
.MEASURE TRAN hd5_v28 FIND V(hd[5]) AT=144.0n
.MEASURE TRAN hd6_v28 FIND V(hd[6]) AT=144.0n
.MEASURE TRAN hd0_v29 FIND V(hd[0]) AT=149.0n
.MEASURE TRAN hd1_v29 FIND V(hd[1]) AT=149.0n
.MEASURE TRAN hd2_v29 FIND V(hd[2]) AT=149.0n
.MEASURE TRAN hd3_v29 FIND V(hd[3]) AT=149.0n
.MEASURE TRAN hd4_v29 FIND V(hd[4]) AT=149.0n
.MEASURE TRAN hd5_v29 FIND V(hd[5]) AT=149.0n
.MEASURE TRAN hd6_v29 FIND V(hd[6]) AT=149.0n
.MEASURE TRAN hd0_v30 FIND V(hd[0]) AT=154.0n
.MEASURE TRAN hd1_v30 FIND V(hd[1]) AT=154.0n
.MEASURE TRAN hd2_v30 FIND V(hd[2]) AT=154.0n
.MEASURE TRAN hd3_v30 FIND V(hd[3]) AT=154.0n
.MEASURE TRAN hd4_v30 FIND V(hd[4]) AT=154.0n
.MEASURE TRAN hd5_v30 FIND V(hd[5]) AT=154.0n
.MEASURE TRAN hd6_v30 FIND V(hd[6]) AT=154.0n
.MEASURE TRAN hd0_v31 FIND V(hd[0]) AT=159.0n
.MEASURE TRAN hd1_v31 FIND V(hd[1]) AT=159.0n
.MEASURE TRAN hd2_v31 FIND V(hd[2]) AT=159.0n
.MEASURE TRAN hd3_v31 FIND V(hd[3]) AT=159.0n
.MEASURE TRAN hd4_v31 FIND V(hd[4]) AT=159.0n
.MEASURE TRAN hd5_v31 FIND V(hd[5]) AT=159.0n
.MEASURE TRAN hd6_v31 FIND V(hd[6]) AT=159.0n
.MEASURE TRAN hd0_v32 FIND V(hd[0]) AT=164.0n
.MEASURE TRAN hd1_v32 FIND V(hd[1]) AT=164.0n
.MEASURE TRAN hd2_v32 FIND V(hd[2]) AT=164.0n
.MEASURE TRAN hd3_v32 FIND V(hd[3]) AT=164.0n
.MEASURE TRAN hd4_v32 FIND V(hd[4]) AT=164.0n
.MEASURE TRAN hd5_v32 FIND V(hd[5]) AT=164.0n
.MEASURE TRAN hd6_v32 FIND V(hd[6]) AT=164.0n
.MEASURE TRAN hd0_v33 FIND V(hd[0]) AT=169.0n
.MEASURE TRAN hd1_v33 FIND V(hd[1]) AT=169.0n
.MEASURE TRAN hd2_v33 FIND V(hd[2]) AT=169.0n
.MEASURE TRAN hd3_v33 FIND V(hd[3]) AT=169.0n
.MEASURE TRAN hd4_v33 FIND V(hd[4]) AT=169.0n
.MEASURE TRAN hd5_v33 FIND V(hd[5]) AT=169.0n
.MEASURE TRAN hd6_v33 FIND V(hd[6]) AT=169.0n
.MEASURE TRAN hd0_v34 FIND V(hd[0]) AT=174.0n
.MEASURE TRAN hd1_v34 FIND V(hd[1]) AT=174.0n
.MEASURE TRAN hd2_v34 FIND V(hd[2]) AT=174.0n
.MEASURE TRAN hd3_v34 FIND V(hd[3]) AT=174.0n
.MEASURE TRAN hd4_v34 FIND V(hd[4]) AT=174.0n
.MEASURE TRAN hd5_v34 FIND V(hd[5]) AT=174.0n
.MEASURE TRAN hd6_v34 FIND V(hd[6]) AT=174.0n
.MEASURE TRAN hd0_v35 FIND V(hd[0]) AT=179.0n
.MEASURE TRAN hd1_v35 FIND V(hd[1]) AT=179.0n
.MEASURE TRAN hd2_v35 FIND V(hd[2]) AT=179.0n
.MEASURE TRAN hd3_v35 FIND V(hd[3]) AT=179.0n
.MEASURE TRAN hd4_v35 FIND V(hd[4]) AT=179.0n
.MEASURE TRAN hd5_v35 FIND V(hd[5]) AT=179.0n
.MEASURE TRAN hd6_v35 FIND V(hd[6]) AT=179.0n
.MEASURE TRAN hd0_v36 FIND V(hd[0]) AT=184.0n
.MEASURE TRAN hd1_v36 FIND V(hd[1]) AT=184.0n
.MEASURE TRAN hd2_v36 FIND V(hd[2]) AT=184.0n
.MEASURE TRAN hd3_v36 FIND V(hd[3]) AT=184.0n
.MEASURE TRAN hd4_v36 FIND V(hd[4]) AT=184.0n
.MEASURE TRAN hd5_v36 FIND V(hd[5]) AT=184.0n
.MEASURE TRAN hd6_v36 FIND V(hd[6]) AT=184.0n
.MEASURE TRAN hd0_v37 FIND V(hd[0]) AT=189.0n
.MEASURE TRAN hd1_v37 FIND V(hd[1]) AT=189.0n
.MEASURE TRAN hd2_v37 FIND V(hd[2]) AT=189.0n
.MEASURE TRAN hd3_v37 FIND V(hd[3]) AT=189.0n
.MEASURE TRAN hd4_v37 FIND V(hd[4]) AT=189.0n
.MEASURE TRAN hd5_v37 FIND V(hd[5]) AT=189.0n
.MEASURE TRAN hd6_v37 FIND V(hd[6]) AT=189.0n
.MEASURE TRAN hd0_v38 FIND V(hd[0]) AT=194.0n
.MEASURE TRAN hd1_v38 FIND V(hd[1]) AT=194.0n
.MEASURE TRAN hd2_v38 FIND V(hd[2]) AT=194.0n
.MEASURE TRAN hd3_v38 FIND V(hd[3]) AT=194.0n
.MEASURE TRAN hd4_v38 FIND V(hd[4]) AT=194.0n
.MEASURE TRAN hd5_v38 FIND V(hd[5]) AT=194.0n
.MEASURE TRAN hd6_v38 FIND V(hd[6]) AT=194.0n
.MEASURE TRAN hd0_v39 FIND V(hd[0]) AT=199.0n
.MEASURE TRAN hd1_v39 FIND V(hd[1]) AT=199.0n
.MEASURE TRAN hd2_v39 FIND V(hd[2]) AT=199.0n
.MEASURE TRAN hd3_v39 FIND V(hd[3]) AT=199.0n
.MEASURE TRAN hd4_v39 FIND V(hd[4]) AT=199.0n
.MEASURE TRAN hd5_v39 FIND V(hd[5]) AT=199.0n
.MEASURE TRAN hd6_v39 FIND V(hd[6]) AT=199.0n
.MEASURE TRAN hd0_v40 FIND V(hd[0]) AT=204.0n
.MEASURE TRAN hd1_v40 FIND V(hd[1]) AT=204.0n
.MEASURE TRAN hd2_v40 FIND V(hd[2]) AT=204.0n
.MEASURE TRAN hd3_v40 FIND V(hd[3]) AT=204.0n
.MEASURE TRAN hd4_v40 FIND V(hd[4]) AT=204.0n
.MEASURE TRAN hd5_v40 FIND V(hd[5]) AT=204.0n
.MEASURE TRAN hd6_v40 FIND V(hd[6]) AT=204.0n
.MEASURE TRAN hd0_v41 FIND V(hd[0]) AT=209.0n
.MEASURE TRAN hd1_v41 FIND V(hd[1]) AT=209.0n
.MEASURE TRAN hd2_v41 FIND V(hd[2]) AT=209.0n
.MEASURE TRAN hd3_v41 FIND V(hd[3]) AT=209.0n
.MEASURE TRAN hd4_v41 FIND V(hd[4]) AT=209.0n
.MEASURE TRAN hd5_v41 FIND V(hd[5]) AT=209.0n
.MEASURE TRAN hd6_v41 FIND V(hd[6]) AT=209.0n
.MEASURE TRAN hd0_v42 FIND V(hd[0]) AT=214.0n
.MEASURE TRAN hd1_v42 FIND V(hd[1]) AT=214.0n
.MEASURE TRAN hd2_v42 FIND V(hd[2]) AT=214.0n
.MEASURE TRAN hd3_v42 FIND V(hd[3]) AT=214.0n
.MEASURE TRAN hd4_v42 FIND V(hd[4]) AT=214.0n
.MEASURE TRAN hd5_v42 FIND V(hd[5]) AT=214.0n
.MEASURE TRAN hd6_v42 FIND V(hd[6]) AT=214.0n
.MEASURE TRAN hd0_v43 FIND V(hd[0]) AT=219.0n
.MEASURE TRAN hd1_v43 FIND V(hd[1]) AT=219.0n
.MEASURE TRAN hd2_v43 FIND V(hd[2]) AT=219.0n
.MEASURE TRAN hd3_v43 FIND V(hd[3]) AT=219.0n
.MEASURE TRAN hd4_v43 FIND V(hd[4]) AT=219.0n
.MEASURE TRAN hd5_v43 FIND V(hd[5]) AT=219.0n
.MEASURE TRAN hd6_v43 FIND V(hd[6]) AT=219.0n
.MEASURE TRAN hd0_v44 FIND V(hd[0]) AT=224.0n
.MEASURE TRAN hd1_v44 FIND V(hd[1]) AT=224.0n
.MEASURE TRAN hd2_v44 FIND V(hd[2]) AT=224.0n
.MEASURE TRAN hd3_v44 FIND V(hd[3]) AT=224.0n
.MEASURE TRAN hd4_v44 FIND V(hd[4]) AT=224.0n
.MEASURE TRAN hd5_v44 FIND V(hd[5]) AT=224.0n
.MEASURE TRAN hd6_v44 FIND V(hd[6]) AT=224.0n
.MEASURE TRAN hd0_v45 FIND V(hd[0]) AT=229.0n
.MEASURE TRAN hd1_v45 FIND V(hd[1]) AT=229.0n
.MEASURE TRAN hd2_v45 FIND V(hd[2]) AT=229.0n
.MEASURE TRAN hd3_v45 FIND V(hd[3]) AT=229.0n
.MEASURE TRAN hd4_v45 FIND V(hd[4]) AT=229.0n
.MEASURE TRAN hd5_v45 FIND V(hd[5]) AT=229.0n
.MEASURE TRAN hd6_v45 FIND V(hd[6]) AT=229.0n
.MEASURE TRAN hd0_v46 FIND V(hd[0]) AT=234.0n
.MEASURE TRAN hd1_v46 FIND V(hd[1]) AT=234.0n
.MEASURE TRAN hd2_v46 FIND V(hd[2]) AT=234.0n
.MEASURE TRAN hd3_v46 FIND V(hd[3]) AT=234.0n
.MEASURE TRAN hd4_v46 FIND V(hd[4]) AT=234.0n
.MEASURE TRAN hd5_v46 FIND V(hd[5]) AT=234.0n
.MEASURE TRAN hd6_v46 FIND V(hd[6]) AT=234.0n
.MEASURE TRAN hd0_v47 FIND V(hd[0]) AT=239.0n
.MEASURE TRAN hd1_v47 FIND V(hd[1]) AT=239.0n
.MEASURE TRAN hd2_v47 FIND V(hd[2]) AT=239.0n
.MEASURE TRAN hd3_v47 FIND V(hd[3]) AT=239.0n
.MEASURE TRAN hd4_v47 FIND V(hd[4]) AT=239.0n
.MEASURE TRAN hd5_v47 FIND V(hd[5]) AT=239.0n
.MEASURE TRAN hd6_v47 FIND V(hd[6]) AT=239.0n
.MEASURE TRAN hd0_v48 FIND V(hd[0]) AT=244.0n
.MEASURE TRAN hd1_v48 FIND V(hd[1]) AT=244.0n
.MEASURE TRAN hd2_v48 FIND V(hd[2]) AT=244.0n
.MEASURE TRAN hd3_v48 FIND V(hd[3]) AT=244.0n
.MEASURE TRAN hd4_v48 FIND V(hd[4]) AT=244.0n
.MEASURE TRAN hd5_v48 FIND V(hd[5]) AT=244.0n
.MEASURE TRAN hd6_v48 FIND V(hd[6]) AT=244.0n
.MEASURE TRAN hd0_v49 FIND V(hd[0]) AT=249.0n
.MEASURE TRAN hd1_v49 FIND V(hd[1]) AT=249.0n
.MEASURE TRAN hd2_v49 FIND V(hd[2]) AT=249.0n
.MEASURE TRAN hd3_v49 FIND V(hd[3]) AT=249.0n
.MEASURE TRAN hd4_v49 FIND V(hd[4]) AT=249.0n
.MEASURE TRAN hd5_v49 FIND V(hd[5]) AT=249.0n
.MEASURE TRAN hd6_v49 FIND V(hd[6]) AT=249.0n

.END
